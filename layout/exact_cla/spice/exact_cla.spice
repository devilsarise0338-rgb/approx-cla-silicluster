* NGSPICE file created from exact_cla.ext - technology: ihp-sg13g2

* Black-box entry subcircuit for sg13g2_decap_8 abstract view
.subckt sg13g2_decap_8 VDD VSS
.ends

* Black-box entry subcircuit for sg13g2_xor2_1 abstract view
.subckt sg13g2_xor2_1 X A B VDD VSS
.ends

* Black-box entry subcircuit for sg13g2_buf_1 abstract view
.subckt sg13g2_buf_1 X A VDD VSS
.ends

* Black-box entry subcircuit for sg13g2_tiehi abstract view
.subckt sg13g2_tiehi L_HI VDD VSS
.ends

* Black-box entry subcircuit for sg13g2_decap_4 abstract view
.subckt sg13g2_decap_4 VDD VSS
.ends

* Black-box entry subcircuit for sg13g2_nor2_1 abstract view
.subckt sg13g2_nor2_1 Y A B VDD VSS
.ends

* Black-box entry subcircuit for sg13g2_fill_1 abstract view
.subckt sg13g2_fill_1 VDD VSS
.ends

* Black-box entry subcircuit for sg13g2_fill_2 abstract view
.subckt sg13g2_fill_2 VDD VSS
.ends

* Black-box entry subcircuit for sg13g2_a21oi_1 abstract view
.subckt sg13g2_a21oi_1 Y A1 A2 B1 VDD VSS
.ends

* Black-box entry subcircuit for sg13g2_dfrbpq_1 abstract view
.subckt sg13g2_dfrbpq_1 Q CLK D RESET_B VDD VSS
.ends

* Black-box entry subcircuit for sg13g2_buf_16 abstract view
.subckt sg13g2_buf_16 X A VDD VSS
.ends

* Black-box entry subcircuit for sg13g2_nand3_1 abstract view
.subckt sg13g2_nand3_1 Y A B C VDD VSS
.ends

* Black-box entry subcircuit for sg13g2_and2_1 abstract view
.subckt sg13g2_and2_1 X A B VDD VSS
.ends

* Black-box entry subcircuit for sg13g2_nand2_1 abstract view
.subckt sg13g2_nand2_1 Y A B VDD VSS
.ends

* Black-box entry subcircuit for sg13g2_inv_1 abstract view
.subckt sg13g2_inv_1 Y A VDD VSS
.ends

* Black-box entry subcircuit for sg13g2_xnor2_1 abstract view
.subckt sg13g2_xnor2_1 Y A B VDD VSS
.ends

* Black-box entry subcircuit for sg13g2_a21o_1 abstract view
.subckt sg13g2_a21o_1 X A1 A2 B1 VDD VSS
.ends

* Black-box entry subcircuit for sg13g2_and3_1 abstract view
.subckt sg13g2_and3_1 X A B C VDD VSS
.ends

* Black-box entry subcircuit for sg13g2_o21ai_1 abstract view
.subckt sg13g2_o21ai_1 Y A1 A2 B1 VDD VSS
.ends

* Black-box entry subcircuit for sg13g2_or3_1 abstract view
.subckt sg13g2_or3_1 X A B C VDD VSS
.ends

* Black-box entry subcircuit for sg13g2_nor3_1 abstract view
.subckt sg13g2_nor3_1 Y A B C VDD VSS
.ends

* Black-box entry subcircuit for sg13g2_nor2b_1 abstract view
.subckt sg13g2_nor2b_1 Y A B_N VDD VSS
.ends

.subckt exact_cla VGND VPWR a[0] a[1] a[2] a[3] a[4] a[5] a[6] b[0] b[1] b[2] b[3]
+ b[4] b[5] b[6] clk rst sum[0] sum[1] sum[2] sum[3] sum[4] sum[5] sum[6] sum[7]
XFILLER_7_7 VPWR VGND sg13g2_decap_8
XFILLER_13_133 VPWR VGND sg13g2_decap_8
XFILLER_9_126 VPWR VGND sg13g2_decap_8
XFILLER_3_56 VPWR VGND sg13g2_decap_8
XFILLER_5_321 VPWR VGND sg13g2_decap_8
XFILLER_12_98 VPWR VGND sg13g2_decap_8
XFILLER_12_21 VPWR VGND sg13g2_decap_8
XFILLER_10_158 VPWR VGND sg13g2_decap_8
XFILLER_2_302 VPWR VGND sg13g2_decap_8
XFILLER_17_280 VPWR VGND sg13g2_decap_8
XFILLER_5_140 VPWR VGND sg13g2_decap_8
XFILLER_15_206 VPWR VGND sg13g2_decap_8
X_062_ _084_/C _089_/A _089_/B VPWR VGND sg13g2_xor2_1
XFILLER_14_294 VPWR VGND sg13g2_decap_8
XFILLER_9_77 VPWR VGND sg13g2_decap_8
XFILLER_0_35 VPWR VGND sg13g2_decap_8
XFILLER_2_154 VPWR VGND sg13g2_decap_8
XFILLER_20_242 VPWR VGND sg13g2_decap_8
XFILLER_18_42 VPWR VGND sg13g2_decap_8
XFILLER_11_275 VPWR VGND sg13g2_decap_8
XFILLER_11_220 VPWR VGND sg13g2_decap_8
XFILLER_7_268 VPWR VGND sg13g2_decap_8
XFILLER_6_290 VPWR VGND sg13g2_decap_8
XFILLER_20_98 VPWR VGND sg13g2_decap_8
XFILLER_20_21 VPWR VGND sg13g2_decap_8
XFILLER_6_56 VPWR VGND sg13g2_decap_8
XFILLER_15_98 VPWR VGND sg13g2_decap_8
XFILLER_15_21 VPWR VGND sg13g2_decap_8
XFILLER_13_304 VPWR VGND sg13g2_decap_8
XFILLER_9_319 VPWR VGND sg13g2_decap_8
Xoutput20 sum[4] _098_/Q VPWR VGND sg13g2_buf_1
XFILLER_16_164 VPWR VGND sg13g2_decap_8
XFILLER_0_252 VPWR VGND sg13g2_decap_8
X_101__26 _101__26/L_HI VPWR VGND sg13g2_tiehi
XFILLER_11_0 VPWR VGND sg13g2_decap_8
XFILLER_10_329 VPWR VGND sg13g2_decap_8
XFILLER_13_112 VPWR VGND sg13g2_decap_8
XFILLER_9_105 VPWR VGND sg13g2_decap_8
XFILLER_3_35 VPWR VGND sg13g2_decap_8
XFILLER_5_300 VPWR VGND sg13g2_decap_8
XFILLER_18_215 VPWR VGND sg13g2_decap_4
XFILLER_12_77 VPWR VGND sg13g2_decap_8
XFILLER_10_126 VPWR VGND sg13g2_decap_8
XFILLER_6_119 VPWR VGND sg13g2_decap_8
XFILLER_5_196 VPWR VGND sg13g2_decap_8
XFILLER_14_273 VPWR VGND sg13g2_decap_8
X_061_ _064_/A _090_/X _088_/B VPWR VGND sg13g2_nor2_1
XFILLER_9_56 VPWR VGND sg13g2_decap_8
XFILLER_0_14 VPWR VGND sg13g2_decap_8
XFILLER_2_133 VPWR VGND sg13g2_decap_8
XFILLER_2_188 VPWR VGND sg13g2_fill_1
XFILLER_20_298 VPWR VGND sg13g2_decap_8
XFILLER_20_221 VPWR VGND sg13g2_decap_8
XFILLER_18_98 VPWR VGND sg13g2_decap_8
XFILLER_18_21 VPWR VGND sg13g2_decap_8
XFILLER_11_254 VPWR VGND sg13g2_decap_8
XFILLER_7_225 VPWR VGND sg13g2_decap_8
XFILLER_15_7 VPWR VGND sg13g2_decap_8
XFILLER_20_77 VPWR VGND sg13g2_decap_8
XFILLER_19_162 VPWR VGND sg13g2_decap_8
XFILLER_19_140 VPWR VGND sg13g2_fill_2
XFILLER_16_346 VPWR VGND sg13g2_decap_4
XFILLER_3_283 VPWR VGND sg13g2_decap_8
XFILLER_6_35 VPWR VGND sg13g2_decap_8
XFILLER_1_209 VPWR VGND sg13g2_fill_1
Xoutput21 sum[5] _099_/Q VPWR VGND sg13g2_buf_1
XFILLER_15_77 VPWR VGND sg13g2_decap_8
XFILLER_0_231 VPWR VGND sg13g2_decap_8
XFILLER_10_308 VPWR VGND sg13g2_decap_8
XFILLER_13_168 VPWR VGND sg13g2_decap_8
XFILLER_8_172 VPWR VGND sg13g2_fill_2
XFILLER_8_161 VPWR VGND sg13g2_decap_8
XFILLER_3_14 VPWR VGND sg13g2_decap_8
XFILLER_12_56 VPWR VGND sg13g2_decap_8
XFILLER_10_105 VPWR VGND sg13g2_decap_8
XFILLER_2_337 VPWR VGND sg13g2_decap_8
XFILLER_18_238 VPWR VGND sg13g2_decap_8
XFILLER_5_175 VPWR VGND sg13g2_decap_8
XFILLER_14_252 VPWR VGND sg13g2_decap_8
XFILLER_9_35 VPWR VGND sg13g2_decap_8
XFILLER_2_112 VPWR VGND sg13g2_decap_8
X_060_ _088_/B _092_/Y _057_/X _059_/A VPWR VGND sg13g2_a21oi_1
XFILLER_20_200 VPWR VGND sg13g2_decap_8
XFILLER_20_277 VPWR VGND sg13g2_decap_8
XFILLER_18_77 VPWR VGND sg13g2_decap_8
XFILLER_7_204 VPWR VGND sg13g2_decap_8
XFILLER_19_344 VPWR VGND sg13g2_decap_8
XFILLER_1_0 VPWR VGND sg13g2_decap_8
XFILLER_20_56 VPWR VGND sg13g2_decap_8
XFILLER_1_91 VPWR VGND sg13g2_decap_8
XFILLER_4_218 VPWR VGND sg13g2_decap_4
XFILLER_16_325 VPWR VGND sg13g2_decap_8
XFILLER_3_262 VPWR VGND sg13g2_decap_8
XFILLER_6_14 VPWR VGND sg13g2_decap_8
XFILLER_19_196 VPWR VGND sg13g2_decap_8
Xoutput22 sum[6] _100_/Q VPWR VGND sg13g2_buf_1
XFILLER_15_56 VPWR VGND sg13g2_decap_8
XFILLER_13_339 VPWR VGND sg13g2_decap_8
XFILLER_0_210 VPWR VGND sg13g2_decap_4
XFILLER_0_298 VPWR VGND sg13g2_decap_8
XFILLER_16_199 VPWR VGND sg13g2_decap_8
XFILLER_8_343 VPWR VGND sg13g2_decap_8
XFILLER_13_147 VPWR VGND sg13g2_decap_8
X_098__24 _098__24/L_HI VPWR VGND sg13g2_tiehi
XFILLER_12_191 VPWR VGND sg13g2_decap_8
XFILLER_8_140 VPWR VGND sg13g2_decap_8
XFILLER_5_335 VPWR VGND sg13g2_decap_8
XFILLER_12_35 VPWR VGND sg13g2_decap_8
XFILLER_2_316 VPWR VGND sg13g2_decap_8
XFILLER_5_7 VPWR VGND sg13g2_decap_8
XFILLER_5_154 VPWR VGND sg13g2_decap_8
XFILLER_17_294 VPWR VGND sg13g2_decap_8
XFILLER_4_91 VPWR VGND sg13g2_decap_8
XFILLER_0_49 VPWR VGND sg13g2_decap_8
XFILLER_2_168 VPWR VGND sg13g2_decap_8
XFILLER_9_14 VPWR VGND sg13g2_decap_8
XFILLER_20_256 VPWR VGND sg13g2_decap_8
XFILLER_18_56 VPWR VGND sg13g2_decap_8
XFILLER_19_323 VPWR VGND sg13g2_decap_8
XFILLER_11_289 VPWR VGND sg13g2_decap_8
XFILLER_1_70 VPWR VGND sg13g2_decap_8
XFILLER_20_35 VPWR VGND sg13g2_decap_8
XFILLER_16_304 VPWR VGND sg13g2_decap_8
XFILLER_3_241 VPWR VGND sg13g2_decap_8
XFILLER_20_7 VPWR VGND sg13g2_decap_8
XFILLER_19_142 VPWR VGND sg13g2_fill_1
Xoutput23 sum[7] _101_/Q VPWR VGND sg13g2_buf_1
XFILLER_15_35 VPWR VGND sg13g2_decap_8
XFILLER_13_318 VPWR VGND sg13g2_decap_8
XFILLER_0_277 VPWR VGND sg13g2_decap_8
XFILLER_0_266 VPWR VGND sg13g2_decap_8
XFILLER_16_178 VPWR VGND sg13g2_decap_8
XFILLER_16_112 VPWR VGND sg13g2_decap_8
XFILLER_8_322 VPWR VGND sg13g2_decap_8
XFILLER_7_91 VPWR VGND sg13g2_decap_8
XFILLER_21_181 VPWR VGND sg13g2_decap_8
XFILLER_13_126 VPWR VGND sg13g2_decap_8
XFILLER_9_119 VPWR VGND sg13g2_decap_8
XFILLER_3_49 VPWR VGND sg13g2_decap_8
XFILLER_5_314 VPWR VGND sg13g2_decap_8
XFILLER_12_14 VPWR VGND sg13g2_decap_8
X_095__28 _095__28/L_HI VPWR VGND sg13g2_tiehi
XFILLER_5_133 VPWR VGND sg13g2_decap_8
XFILLER_17_273 VPWR VGND sg13g2_decap_8
XFILLER_1_350 VPWR VGND sg13g2_fill_1
XFILLER_2_147 VPWR VGND sg13g2_decap_8
XFILLER_4_70 VPWR VGND sg13g2_decap_8
XFILLER_14_287 VPWR VGND sg13g2_decap_8
XFILLER_14_210 VPWR VGND sg13g2_fill_1
XFILLER_0_28 VPWR VGND sg13g2_decap_8
XFILLER_20_235 VPWR VGND sg13g2_decap_8
XFILLER_18_35 VPWR VGND sg13g2_decap_8
XFILLER_9_291 VPWR VGND sg13g2_decap_8
XFILLER_19_302 VPWR VGND sg13g2_decap_8
XFILLER_11_268 VPWR VGND sg13g2_decap_8
XFILLER_11_213 VPWR VGND sg13g2_decap_8
XFILLER_7_239 VPWR VGND sg13g2_decap_4
XFILLER_6_283 VPWR VGND sg13g2_decap_8
XFILLER_20_14 VPWR VGND sg13g2_decap_8
XFILLER_19_176 VPWR VGND sg13g2_fill_2
XFILLER_13_7 VPWR VGND sg13g2_decap_8
XFILLER_10_91 VPWR VGND sg13g2_decap_8
XFILLER_3_297 VPWR VGND sg13g2_decap_8
XFILLER_6_49 VPWR VGND sg13g2_decap_8
XFILLER_15_14 VPWR VGND sg13g2_decap_8
XFILLER_16_157 VPWR VGND sg13g2_decap_8
XFILLER_16_146 VPWR VGND sg13g2_fill_1
XFILLER_16_135 VPWR VGND sg13g2_decap_4
XFILLER_8_301 VPWR VGND sg13g2_decap_8
XFILLER_0_245 VPWR VGND sg13g2_decap_8
XFILLER_7_70 VPWR VGND sg13g2_decap_8
XFILLER_13_105 VPWR VGND sg13g2_decap_8
XFILLER_3_28 VPWR VGND sg13g2_decap_8
XFILLER_18_219 VPWR VGND sg13g2_fill_1
XFILLER_18_208 VPWR VGND sg13g2_decap_8
XFILLER_10_119 VPWR VGND sg13g2_decap_8
XFILLER_17_252 VPWR VGND sg13g2_decap_8
XFILLER_5_112 VPWR VGND sg13g2_decap_8
XFILLER_5_189 VPWR VGND sg13g2_decap_8
XFILLER_14_266 VPWR VGND sg13g2_decap_8
XFILLER_13_91 VPWR VGND sg13g2_decap_8
XFILLER_9_49 VPWR VGND sg13g2_decap_8
XFILLER_2_126 VPWR VGND sg13g2_decap_8
XFILLER_20_214 VPWR VGND sg13g2_decap_8
XFILLER_1_181 VPWR VGND sg13g2_decap_8
XFILLER_18_14 VPWR VGND sg13g2_decap_8
XFILLER_7_218 VPWR VGND sg13g2_decap_8
XFILLER_10_280 VPWR VGND sg13g2_decap_8
XFILLER_16_339 VPWR VGND sg13g2_decap_8
XFILLER_19_155 VPWR VGND sg13g2_decap_8
XFILLER_19_133 VPWR VGND sg13g2_decap_8
XFILLER_15_350 VPWR VGND sg13g2_fill_1
XFILLER_10_70 VPWR VGND sg13g2_decap_8
XFILLER_3_210 VPWR VGND sg13g2_decap_8
XFILLER_3_221 VPWR VGND sg13g2_fill_1
XFILLER_3_276 VPWR VGND sg13g2_decap_8
XFILLER_6_28 VPWR VGND sg13g2_decap_8
XFILLER_21_331 VPWR VGND sg13g2_decap_8
XFILLER_21_91 VPWR VGND sg13g2_decap_8
XFILLER_12_331 VPWR VGND sg13g2_decap_8
XFILLER_21_172 VPWR VGND sg13g2_fill_1
XFILLER_21_161 VPWR VGND sg13g2_decap_8
XFILLER_5_349 VPWR VGND sg13g2_fill_2
XFILLER_16_91 VPWR VGND sg13g2_decap_8
XFILLER_12_161 VPWR VGND sg13g2_decap_8
XFILLER_8_154 VPWR VGND sg13g2_decap_8
XFILLER_12_49 VPWR VGND sg13g2_decap_8
X_094__30 _094__30/L_HI VPWR VGND sg13g2_tiehi
XFILLER_17_231 VPWR VGND sg13g2_decap_8
XFILLER_1_341 VPWR VGND sg13g2_decap_8
XFILLER_5_168 VPWR VGND sg13g2_decap_8
XFILLER_4_190 VPWR VGND sg13g2_decap_8
XFILLER_14_245 VPWR VGND sg13g2_decap_8
XFILLER_13_70 VPWR VGND sg13g2_decap_8
XFILLER_9_28 VPWR VGND sg13g2_decap_8
XFILLER_2_105 VPWR VGND sg13g2_decap_8
XFILLER_3_7 VPWR VGND sg13g2_decap_8
XFILLER_1_160 VPWR VGND sg13g2_decap_8
XFILLER_19_337 VPWR VGND sg13g2_decap_8
X_099_ _099_/Q _101_/CLK _099_/D _099__25/L_HI VPWR VGND sg13g2_dfrbpq_1
XFILLER_6_252 VPWR VGND sg13g2_decap_4
XFILLER_20_49 VPWR VGND sg13g2_decap_8
XFILLER_1_84 VPWR VGND sg13g2_decap_8
XFILLER_19_189 VPWR VGND sg13g2_decap_8
XFILLER_19_112 VPWR VGND sg13g2_decap_8
XFILLER_19_91 VPWR VGND sg13g2_decap_8
XFILLER_16_318 VPWR VGND sg13g2_decap_8
XFILLER_3_255 VPWR VGND sg13g2_decap_8
XFILLER_21_310 VPWR VGND sg13g2_decap_8
XFILLER_15_49 VPWR VGND sg13g2_decap_8
XFILLER_16_126 VPWR VGND sg13g2_decap_4
XFILLER_12_310 VPWR VGND sg13g2_decap_8
XFILLER_8_336 VPWR VGND sg13g2_decap_8
XFILLER_0_214 VPWR VGND sg13g2_fill_1
XFILLER_0_203 VPWR VGND sg13g2_decap_8
XFILLER_21_70 VPWR VGND sg13g2_decap_8
XFILLER_15_192 VPWR VGND sg13g2_decap_8
XFILLER_21_195 VPWR VGND sg13g2_decap_4
XFILLER_5_328 VPWR VGND sg13g2_decap_8
XFILLER_16_70 VPWR VGND sg13g2_decap_8
XFILLER_12_184 VPWR VGND sg13g2_decap_8
XFILLER_12_140 VPWR VGND sg13g2_decap_8
XFILLER_8_133 VPWR VGND sg13g2_decap_8
XFILLER_12_28 VPWR VGND sg13g2_decap_8
XFILLER_2_309 VPWR VGND sg13g2_decap_8
XFILLER_17_210 VPWR VGND sg13g2_decap_8
XFILLER_1_320 VPWR VGND sg13g2_decap_8
XFILLER_5_147 VPWR VGND sg13g2_decap_8
XFILLER_17_287 VPWR VGND sg13g2_decap_8
XFILLER_4_84 VPWR VGND sg13g2_decap_8
XFILLER_20_249 VPWR VGND sg13g2_decap_8
XFILLER_13_290 VPWR VGND sg13g2_decap_8
XFILLER_18_49 VPWR VGND sg13g2_decap_8
XFILLER_11_227 VPWR VGND sg13g2_fill_2
XFILLER_19_316 VPWR VGND sg13g2_decap_8
X_098_ _098_/Q _101_/CLK _098_/D _098__24/L_HI VPWR VGND sg13g2_dfrbpq_1
XFILLER_6_231 VPWR VGND sg13g2_decap_8
XFILLER_6_297 VPWR VGND sg13g2_decap_8
XFILLER_20_28 VPWR VGND sg13g2_decap_8
XFILLER_1_63 VPWR VGND sg13g2_decap_8
XFILLER_3_234 VPWR VGND sg13g2_decap_8
XFILLER_19_70 VPWR VGND sg13g2_decap_8
XFILLER_18_0 VPWR VGND sg13g2_decap_8
XFILLER_16_105 VPWR VGND sg13g2_decap_8
XFILLER_15_28 VPWR VGND sg13g2_decap_8
Xoutput16 sum[0] _094_/Q VPWR VGND sg13g2_buf_1
XFILLER_0_259 VPWR VGND sg13g2_decap_8
XFILLER_15_171 VPWR VGND sg13g2_decap_8
Xclkbuf_0_clk clkbuf_0_clk/X clk VPWR VGND sg13g2_buf_16
XFILLER_11_7 VPWR VGND sg13g2_decap_8
XFILLER_8_315 VPWR VGND sg13g2_decap_8
XFILLER_13_119 VPWR VGND sg13g2_decap_8
XFILLER_7_84 VPWR VGND sg13g2_decap_8
XFILLER_8_112 VPWR VGND sg13g2_decap_8
XFILLER_5_307 VPWR VGND sg13g2_decap_8
XFILLER_5_126 VPWR VGND sg13g2_decap_8
XFILLER_17_266 VPWR VGND sg13g2_decap_8
XFILLER_4_63 VPWR VGND sg13g2_decap_8
XFILLER_14_203 VPWR VGND sg13g2_decap_8
XFILLER_1_195 VPWR VGND sg13g2_decap_8
XFILLER_20_228 VPWR VGND sg13g2_decap_8
XFILLER_18_28 VPWR VGND sg13g2_decap_8
XFILLER_11_206 VPWR VGND sg13g2_decap_8
XFILLER_9_284 VPWR VGND sg13g2_decap_8
XFILLER_6_210 VPWR VGND sg13g2_decap_8
XFILLER_10_294 VPWR VGND sg13g2_decap_8
X_097_ _097_/Q _097_/CLK _097_/D _097__31/L_HI VPWR VGND sg13g2_dfrbpq_1
XFILLER_1_42 VPWR VGND sg13g2_decap_8
XFILLER_19_169 VPWR VGND sg13g2_decap_8
XFILLER_10_84 VPWR VGND sg13g2_decap_8
XFILLER_21_345 VPWR VGND sg13g2_decap_4
XFILLER_18_191 VPWR VGND sg13g2_fill_2
Xoutput17 sum[1] _095_/Q VPWR VGND sg13g2_buf_1
XFILLER_0_238 VPWR VGND sg13g2_decap_8
XFILLER_16_139 VPWR VGND sg13g2_fill_2
XFILLER_12_345 VPWR VGND sg13g2_decap_4
XFILLER_15_150 VPWR VGND sg13g2_decap_8
XFILLER_7_63 VPWR VGND sg13g2_decap_8
XFILLER_21_131 VPWR VGND sg13g2_decap_8
XFILLER_12_175 VPWR VGND sg13g2_decap_4
XFILLER_8_168 VPWR VGND sg13g2_decap_4
XFILLER_7_190 VPWR VGND sg13g2_decap_8
XFILLER_5_105 VPWR VGND sg13g2_decap_8
XFILLER_17_245 VPWR VGND sg13g2_decap_8
XFILLER_4_42 VPWR VGND sg13g2_decap_8
XFILLER_2_119 VPWR VGND sg13g2_decap_8
XFILLER_14_259 VPWR VGND sg13g2_decap_8
XFILLER_13_84 VPWR VGND sg13g2_decap_8
XFILLER_8_0 VPWR VGND sg13g2_decap_8
XFILLER_1_174 VPWR VGND sg13g2_decap_8
XFILLER_20_207 VPWR VGND sg13g2_decap_8
XFILLER_1_7 VPWR VGND sg13g2_decap_8
XFILLER_18_340 VPWR VGND sg13g2_decap_8
XFILLER_10_273 VPWR VGND sg13g2_decap_8
X_096_ _096_/Q _097_/CLK _096_/D _096__27/L_HI VPWR VGND sg13g2_dfrbpq_1
XFILLER_1_98 VPWR VGND sg13g2_decap_8
XFILLER_1_21 VPWR VGND sg13g2_decap_8
XFILLER_19_148 VPWR VGND sg13g2_decap_8
XFILLER_19_126 VPWR VGND sg13g2_decap_8
XFILLER_15_343 VPWR VGND sg13g2_decap_8
XFILLER_10_63 VPWR VGND sg13g2_decap_8
XFILLER_3_203 VPWR VGND sg13g2_decap_8
XFILLER_3_269 VPWR VGND sg13g2_decap_8
XFILLER_21_324 VPWR VGND sg13g2_decap_8
Xoutput18 sum[2] _096_/Q VPWR VGND sg13g2_buf_1
X_079_ _080_/B _088_/A _087_/B VPWR VGND sg13g2_nor2_1
XFILLER_21_84 VPWR VGND sg13g2_decap_8
XFILLER_12_324 VPWR VGND sg13g2_decap_8
XFILLER_7_42 VPWR VGND sg13g2_decap_8
XFILLER_21_154 VPWR VGND sg13g2_decap_8
X_097__31 _097__31/L_HI VPWR VGND sg13g2_tiehi
XFILLER_16_84 VPWR VGND sg13g2_decap_8
XFILLER_12_198 VPWR VGND sg13g2_decap_8
XFILLER_12_154 VPWR VGND sg13g2_decap_8
XFILLER_8_147 VPWR VGND sg13g2_decap_8
XFILLER_4_331 VPWR VGND sg13g2_decap_8
XFILLER_17_224 VPWR VGND sg13g2_decap_8
XFILLER_1_334 VPWR VGND sg13g2_decap_8
XFILLER_16_290 VPWR VGND sg13g2_decap_8
XFILLER_4_21 VPWR VGND sg13g2_decap_8
XFILLER_4_98 VPWR VGND sg13g2_decap_8
XFILLER_4_183 VPWR VGND sg13g2_decap_8
XFILLER_14_238 VPWR VGND sg13g2_decap_8
XFILLER_13_63 VPWR VGND sg13g2_decap_8
XFILLER_9_231 VPWR VGND sg13g2_decap_8
XFILLER_1_153 VPWR VGND sg13g2_decap_8
XFILLER_1_77 VPWR VGND sg13g2_decap_8
XFILLER_6_245 VPWR VGND sg13g2_decap_8
X_095_ _095_/Q _097_/CLK _095_/D _095__28/L_HI VPWR VGND sg13g2_dfrbpq_1
XFILLER_19_84 VPWR VGND sg13g2_decap_8
XFILLER_19_105 VPWR VGND sg13g2_decap_8
XFILLER_15_322 VPWR VGND sg13g2_decap_8
XFILLER_10_42 VPWR VGND sg13g2_decap_8
XFILLER_3_248 VPWR VGND sg13g2_decap_8
XFILLER_21_303 VPWR VGND sg13g2_decap_8
X_078_ _080_/A _093_/Y _078_/B _078_/C VPWR VGND sg13g2_nand3_1
XFILLER_2_281 VPWR VGND sg13g2_decap_8
XFILLER_21_63 VPWR VGND sg13g2_decap_8
XFILLER_16_119 VPWR VGND sg13g2_decap_8
XFILLER_12_303 VPWR VGND sg13g2_decap_8
XFILLER_8_329 VPWR VGND sg13g2_decap_8
Xoutput19 sum[3] _097_/Q VPWR VGND sg13g2_buf_1
XFILLER_15_185 VPWR VGND sg13g2_decap_8
XFILLER_15_141 VPWR VGND sg13g2_decap_4
XFILLER_7_98 VPWR VGND sg13g2_decap_8
XFILLER_7_21 VPWR VGND sg13g2_decap_8
XFILLER_21_199 VPWR VGND sg13g2_fill_2
XFILLER_21_188 VPWR VGND sg13g2_decap_8
XFILLER_16_0 VPWR VGND sg13g2_decap_8
XFILLER_16_63 VPWR VGND sg13g2_decap_8
XFILLER_12_133 VPWR VGND sg13g2_decap_8
XFILLER_8_126 VPWR VGND sg13g2_decap_8
XFILLER_4_310 VPWR VGND sg13g2_decap_8
XFILLER_17_203 VPWR VGND sg13g2_decap_8
XFILLER_1_313 VPWR VGND sg13g2_decap_8
XFILLER_4_77 VPWR VGND sg13g2_decap_8
XFILLER_4_140 VPWR VGND sg13g2_fill_1
XFILLER_4_162 VPWR VGND sg13g2_decap_8
XFILLER_13_42 VPWR VGND sg13g2_decap_8
XFILLER_13_283 VPWR VGND sg13g2_decap_8
XFILLER_9_298 VPWR VGND sg13g2_decap_8
XFILLER_9_210 VPWR VGND sg13g2_decap_8
XFILLER_1_143 VPWR VGND sg13g2_fill_2
XFILLER_1_132 VPWR VGND sg13g2_decap_8
XFILLER_19_309 VPWR VGND sg13g2_decap_8
X_094_ _094_/Q _097_/CLK _094_/D _094__30/L_HI VPWR VGND sg13g2_dfrbpq_1
XFILLER_10_253 VPWR VGND sg13g2_fill_2
XFILLER_10_242 VPWR VGND sg13g2_decap_8
XFILLER_6_224 VPWR VGND sg13g2_decap_8
XFILLER_1_56 VPWR VGND sg13g2_decap_8
XFILLER_19_63 VPWR VGND sg13g2_decap_8
XFILLER_15_301 VPWR VGND sg13g2_decap_8
XFILLER_10_98 VPWR VGND sg13g2_decap_8
XFILLER_10_21 VPWR VGND sg13g2_decap_8
XFILLER_3_227 VPWR VGND sg13g2_decap_8
XFILLER_18_161 VPWR VGND sg13g2_decap_4
XFILLER_2_260 VPWR VGND sg13g2_decap_8
X_077_ _095_/D _078_/B _077_/B VPWR VGND sg13g2_and2_1
XFILLER_8_308 VPWR VGND sg13g2_decap_8
XFILLER_21_42 VPWR VGND sg13g2_decap_8
XFILLER_15_164 VPWR VGND sg13g2_fill_2
XFILLER_7_77 VPWR VGND sg13g2_decap_8
XFILLER_21_112 VPWR VGND sg13g2_decap_8
XFILLER_16_42 VPWR VGND sg13g2_decap_8
XFILLER_12_112 VPWR VGND sg13g2_decap_8
XFILLER_8_105 VPWR VGND sg13g2_decap_8
XFILLER_5_119 VPWR VGND sg13g2_decap_8
XFILLER_17_259 VPWR VGND sg13g2_decap_8
XFILLER_4_56 VPWR VGND sg13g2_decap_8
XFILLER_13_262 VPWR VGND sg13g2_decap_8
XFILLER_13_98 VPWR VGND sg13g2_decap_8
XFILLER_13_21 VPWR VGND sg13g2_decap_8
XFILLER_9_277 VPWR VGND sg13g2_decap_8
XFILLER_1_188 VPWR VGND sg13g2_decap_8
XFILLER_10_287 VPWR VGND sg13g2_decap_8
XFILLER_10_221 VPWR VGND sg13g2_decap_8
X_093_ _093_/Y _093_/A _093_/B VPWR VGND sg13g2_nand2_1
XFILLER_6_0 VPWR VGND sg13g2_decap_8
XFILLER_6_203 VPWR VGND sg13g2_decap_8
XFILLER_1_35 VPWR VGND sg13g2_decap_8
XFILLER_19_42 VPWR VGND sg13g2_decap_8
XFILLER_10_77 VPWR VGND sg13g2_decap_8
Xinput1 _054_/A a[0] VPWR VGND sg13g2_buf_1
XFILLER_3_217 VPWR VGND sg13g2_decap_4
XFILLER_18_140 VPWR VGND sg13g2_decap_8
X_076_ _077_/B _088_/A _076_/B VPWR VGND sg13g2_nor2_1
XFILLER_21_349 VPWR VGND sg13g2_fill_2
XFILLER_21_338 VPWR VGND sg13g2_decap_8
XFILLER_18_184 VPWR VGND sg13g2_decap_8
XFILLER_21_98 VPWR VGND sg13g2_decap_8
XFILLER_21_21 VPWR VGND sg13g2_decap_8
XFILLER_12_349 VPWR VGND sg13g2_fill_2
XFILLER_12_338 VPWR VGND sg13g2_decap_8
XFILLER_21_168 VPWR VGND sg13g2_decap_4
XFILLER_7_331 VPWR VGND sg13g2_decap_8
XFILLER_7_56 VPWR VGND sg13g2_decap_8
X_059_ _087_/C _059_/A VPWR VGND sg13g2_inv_1
XFILLER_16_98 VPWR VGND sg13g2_decap_8
XFILLER_16_21 VPWR VGND sg13g2_decap_8
XFILLER_12_179 VPWR VGND sg13g2_fill_1
XFILLER_12_168 VPWR VGND sg13g2_decap_8
XFILLER_7_183 VPWR VGND sg13g2_decap_8
XFILLER_7_172 VPWR VGND sg13g2_decap_8
XFILLER_4_345 VPWR VGND sg13g2_decap_4
XFILLER_21_0 VPWR VGND sg13g2_decap_8
XFILLER_1_348 VPWR VGND sg13g2_fill_2
XFILLER_17_238 VPWR VGND sg13g2_decap_8
XFILLER_4_35 VPWR VGND sg13g2_decap_8
XFILLER_4_197 VPWR VGND sg13g2_decap_8
XFILLER_13_77 VPWR VGND sg13g2_decap_8
XFILLER_1_167 VPWR VGND sg13g2_decap_8
XFILLER_1_112 VPWR VGND sg13g2_decap_8
XFILLER_13_241 VPWR VGND sg13g2_decap_8
XFILLER_9_245 VPWR VGND sg13g2_decap_4
XFILLER_10_266 VPWR VGND sg13g2_decap_8
XFILLER_10_200 VPWR VGND sg13g2_decap_8
XFILLER_18_333 VPWR VGND sg13g2_decap_8
XFILLER_1_14 VPWR VGND sg13g2_decap_8
X_092_ _092_/Y _092_/A _092_/B VPWR VGND sg13g2_nand2_1
XFILLER_10_56 VPWR VGND sg13g2_decap_8
Xinput2 _093_/A a[1] VPWR VGND sg13g2_buf_1
XFILLER_19_119 VPWR VGND sg13g2_decap_8
XFILLER_19_98 VPWR VGND sg13g2_decap_8
XFILLER_19_21 VPWR VGND sg13g2_decap_8
XFILLER_15_336 VPWR VGND sg13g2_decap_8
XFILLER_2_240 VPWR VGND sg13g2_decap_8
XFILLER_2_295 VPWR VGND sg13g2_decap_8
X_075_ _076_/B _054_/A _054_/B _054_/C VPWR VGND sg13g2_a21oi_1
XFILLER_21_317 VPWR VGND sg13g2_decap_8
XFILLER_21_77 VPWR VGND sg13g2_decap_8
XFILLER_12_317 VPWR VGND sg13g2_decap_8
XFILLER_15_199 VPWR VGND sg13g2_decap_8
XFILLER_7_310 VPWR VGND sg13g2_decap_8
XFILLER_7_35 VPWR VGND sg13g2_decap_8
X_058_ _059_/A _090_/A _090_/B VPWR VGND sg13g2_xnor2_1
XFILLER_21_147 VPWR VGND sg13g2_decap_8
XFILLER_16_77 VPWR VGND sg13g2_decap_8
XFILLER_12_147 VPWR VGND sg13g2_decap_8
XFILLER_7_140 VPWR VGND sg13g2_decap_8
XFILLER_4_324 VPWR VGND sg13g2_decap_8
XFILLER_14_0 VPWR VGND sg13g2_decap_8
XFILLER_7_151 VPWR VGND sg13g2_fill_2
XFILLER_17_217 VPWR VGND sg13g2_decap_8
XFILLER_1_327 VPWR VGND sg13g2_decap_8
XFILLER_4_14 VPWR VGND sg13g2_decap_8
XFILLER_4_176 VPWR VGND sg13g2_decap_8
XFILLER_16_283 VPWR VGND sg13g2_decap_8
XFILLER_13_56 VPWR VGND sg13g2_decap_8
XFILLER_13_297 VPWR VGND sg13g2_decap_8
XFILLER_13_220 VPWR VGND sg13g2_decap_8
XFILLER_9_224 VPWR VGND sg13g2_decap_8
XFILLER_18_312 VPWR VGND sg13g2_decap_8
X_091_ _091_/X _092_/A _092_/B VPWR VGND sg13g2_and2_1
XFILLER_6_238 VPWR VGND sg13g2_decap_8
Xinput3 _092_/A a[2] VPWR VGND sg13g2_buf_1
XFILLER_5_293 VPWR VGND sg13g2_decap_8
X_074_ _074_/X _074_/A _074_/B VPWR VGND sg13g2_and2_1
XFILLER_19_77 VPWR VGND sg13g2_decap_8
XFILLER_15_315 VPWR VGND sg13g2_decap_8
XFILLER_10_35 VPWR VGND sg13g2_decap_8
XFILLER_18_7 VPWR VGND sg13g2_decap_8
XFILLER_2_274 VPWR VGND sg13g2_decap_8
XFILLER_21_56 VPWR VGND sg13g2_decap_8
XFILLER_20_340 VPWR VGND sg13g2_decap_8
XFILLER_2_91 VPWR VGND sg13g2_decap_8
XFILLER_15_178 VPWR VGND sg13g2_decap_8
XFILLER_15_112 VPWR VGND sg13g2_decap_8
X_057_ _057_/X _093_/Y _078_/B _078_/C VPWR VGND sg13g2_a21o_1
XFILLER_7_14 VPWR VGND sg13g2_decap_8
X_100__29 _100__29/L_HI VPWR VGND sg13g2_tiehi
XFILLER_20_170 VPWR VGND sg13g2_fill_1
XFILLER_16_56 VPWR VGND sg13g2_decap_8
XFILLER_12_126 VPWR VGND sg13g2_decap_8
XFILLER_8_119 VPWR VGND sg13g2_decap_8
XFILLER_4_303 VPWR VGND sg13g2_decap_8
XFILLER_19_281 VPWR VGND sg13g2_decap_8
XFILLER_11_192 VPWR VGND sg13g2_decap_8
XFILLER_1_306 VPWR VGND sg13g2_decap_8
XFILLER_16_262 VPWR VGND sg13g2_decap_8
XFILLER_4_133 VPWR VGND sg13g2_decap_8
XFILLER_4_155 VPWR VGND sg13g2_decap_8
XFILLER_13_35 VPWR VGND sg13g2_decap_8
XFILLER_13_276 VPWR VGND sg13g2_decap_8
XFILLER_9_203 VPWR VGND sg13g2_decap_8
XFILLER_0_180 VPWR VGND sg13g2_decap_8
XFILLER_8_280 VPWR VGND sg13g2_decap_8
XFILLER_5_91 VPWR VGND sg13g2_decap_8
XFILLER_10_235 VPWR VGND sg13g2_decap_8
X_090_ _090_/X _090_/A _090_/B VPWR VGND sg13g2_and2_1
XFILLER_1_49 VPWR VGND sg13g2_decap_8
XFILLER_6_217 VPWR VGND sg13g2_decap_8
Xinput4 _090_/A a[3] VPWR VGND sg13g2_buf_1
XFILLER_5_272 VPWR VGND sg13g2_decap_8
XFILLER_19_56 VPWR VGND sg13g2_decap_8
XFILLER_10_14 VPWR VGND sg13g2_decap_8
X_073_ _100_/D _073_/A _073_/B _073_/C VPWR VGND sg13g2_and3_1
XFILLER_18_154 VPWR VGND sg13g2_decap_8
XFILLER_4_0 VPWR VGND sg13g2_decap_8
XFILLER_21_35 VPWR VGND sg13g2_decap_8
XFILLER_2_70 VPWR VGND sg13g2_decap_8
XFILLER_15_157 VPWR VGND sg13g2_decap_8
XFILLER_7_345 VPWR VGND sg13g2_fill_2
X_056_ _087_/B _093_/Y _078_/B _078_/C VPWR VGND sg13g2_a21oi_1
XFILLER_21_138 VPWR VGND sg13g2_fill_1
XFILLER_21_105 VPWR VGND sg13g2_decap_8
XFILLER_20_193 VPWR VGND sg13g2_decap_8
XFILLER_16_35 VPWR VGND sg13g2_decap_8
XFILLER_12_105 VPWR VGND sg13g2_decap_8
XFILLER_11_171 VPWR VGND sg13g2_decap_8
XFILLER_7_197 VPWR VGND sg13g2_decap_8
XFILLER_8_91 VPWR VGND sg13g2_decap_8
XFILLER_16_241 VPWR VGND sg13g2_decap_8
XFILLER_0_340 VPWR VGND sg13g2_decap_8
XFILLER_4_49 VPWR VGND sg13g2_decap_8
XFILLER_4_112 VPWR VGND sg13g2_decap_8
XFILLER_13_14 VPWR VGND sg13g2_decap_8
XFILLER_13_255 VPWR VGND sg13g2_decap_8
XFILLER_8_7 VPWR VGND sg13g2_decap_8
XFILLER_5_70 VPWR VGND sg13g2_decap_8
XFILLER_10_214 VPWR VGND sg13g2_decap_8
XFILLER_1_28 VPWR VGND sg13g2_decap_8
Xinput5 _089_/A a[4] VPWR VGND sg13g2_buf_1
XFILLER_18_347 VPWR VGND sg13g2_decap_4
XFILLER_19_35 VPWR VGND sg13g2_decap_8
X_072_ _073_/C _074_/X _083_/B _071_/C VPWR VGND sg13g2_o21ai_1
XFILLER_18_177 VPWR VGND sg13g2_decap_8
XFILLER_18_133 VPWR VGND sg13g2_decap_8
XFILLER_14_350 VPWR VGND sg13g2_fill_1
XFILLER_2_254 VPWR VGND sg13g2_fill_2
XFILLER_21_14 VPWR VGND sg13g2_decap_8
XFILLER_11_331 VPWR VGND sg13g2_decap_8
XFILLER_7_324 VPWR VGND sg13g2_decap_8
XFILLER_7_49 VPWR VGND sg13g2_decap_8
X_055_ _078_/C _092_/A _092_/B VPWR VGND sg13g2_xnor2_1
XFILLER_11_91 VPWR VGND sg13g2_decap_8
XFILLER_16_14 VPWR VGND sg13g2_decap_8
XFILLER_4_338 VPWR VGND sg13g2_decap_8
XFILLER_4_349 VPWR VGND sg13g2_fill_2
XFILLER_7_165 VPWR VGND sg13g2_decap_8
XFILLER_8_70 VPWR VGND sg13g2_decap_8
XFILLER_16_220 VPWR VGND sg13g2_decap_8
XFILLER_4_28 VPWR VGND sg13g2_decap_8
XFILLER_16_297 VPWR VGND sg13g2_decap_8
XFILLER_12_0 VPWR VGND sg13g2_decap_8
XFILLER_13_234 VPWR VGND sg13g2_decap_8
XFILLER_9_249 VPWR VGND sg13g2_fill_1
XFILLER_9_238 VPWR VGND sg13g2_decap_8
XFILLER_1_105 VPWR VGND sg13g2_decap_8
XFILLER_10_259 VPWR VGND sg13g2_decap_8
XFILLER_18_326 VPWR VGND sg13g2_decap_8
XFILLER_14_91 VPWR VGND sg13g2_decap_8
XFILLER_5_241 VPWR VGND sg13g2_decap_8
Xinput6 _074_/A a[5] VPWR VGND sg13g2_buf_1
XFILLER_19_14 VPWR VGND sg13g2_decap_8
XFILLER_10_49 VPWR VGND sg13g2_decap_8
X_071_ _073_/B _074_/X _083_/B _071_/C VPWR VGND sg13g2_or3_1
XFILLER_18_112 VPWR VGND sg13g2_decap_8
XFILLER_15_329 VPWR VGND sg13g2_decap_8
XFILLER_2_233 VPWR VGND sg13g2_decap_8
XFILLER_2_288 VPWR VGND sg13g2_decap_8
XFILLER_15_126 VPWR VGND sg13g2_fill_2
XFILLER_11_310 VPWR VGND sg13g2_decap_8
XFILLER_16_7 VPWR VGND sg13g2_decap_8
XFILLER_11_70 VPWR VGND sg13g2_decap_8
XFILLER_7_303 VPWR VGND sg13g2_decap_8
XFILLER_7_28 VPWR VGND sg13g2_decap_8
X_054_ _078_/B _054_/A _054_/B _054_/C VPWR VGND sg13g2_nand3_1
XFILLER_4_317 VPWR VGND sg13g2_decap_8
XFILLER_11_151 VPWR VGND sg13g2_fill_1
XFILLER_11_140 VPWR VGND sg13g2_fill_2
XFILLER_7_133 VPWR VGND sg13g2_decap_8
XFILLER_3_350 VPWR VGND sg13g2_fill_1
XFILLER_19_295 VPWR VGND sg13g2_decap_8
XFILLER_4_169 VPWR VGND sg13g2_decap_8
XFILLER_17_91 VPWR VGND sg13g2_decap_8
XFILLER_16_276 VPWR VGND sg13g2_decap_8
XFILLER_13_202 VPWR VGND sg13g2_decap_8
XFILLER_13_49 VPWR VGND sg13g2_decap_8
XFILLER_1_139 VPWR VGND sg13g2_decap_4
XFILLER_9_217 VPWR VGND sg13g2_decap_8
XFILLER_0_194 VPWR VGND sg13g2_decap_4
XFILLER_10_249 VPWR VGND sg13g2_decap_4
XFILLER_8_294 VPWR VGND sg13g2_decap_8
XFILLER_18_305 VPWR VGND sg13g2_decap_8
XFILLER_14_70 VPWR VGND sg13g2_decap_8
Xinput7 _070_/A a[6] VPWR VGND sg13g2_buf_1
XFILLER_10_28 VPWR VGND sg13g2_decap_8
XFILLER_5_286 VPWR VGND sg13g2_decap_8
X_070_ _071_/C _070_/A _070_/B VPWR VGND sg13g2_xor2_1
XFILLER_15_308 VPWR VGND sg13g2_decap_8
XFILLER_2_201 VPWR VGND sg13g2_decap_8
XFILLER_2_267 VPWR VGND sg13g2_decap_8
XFILLER_2_84 VPWR VGND sg13g2_decap_8
XFILLER_21_49 VPWR VGND sg13g2_decap_8
XFILLER_20_333 VPWR VGND sg13g2_decap_8
XFILLER_15_105 VPWR VGND sg13g2_decap_8
X_053_ _054_/C _093_/A _093_/B VPWR VGND sg13g2_xor2_1
XFILLER_2_0 VPWR VGND sg13g2_decap_8
XFILLER_21_119 VPWR VGND sg13g2_decap_4
XFILLER_16_49 VPWR VGND sg13g2_decap_8
XFILLER_14_182 VPWR VGND sg13g2_decap_8
XFILLER_12_119 VPWR VGND sg13g2_decap_8
Xinput10 _092_/B b[2] VPWR VGND sg13g2_buf_1
XFILLER_20_152 VPWR VGND sg13g2_decap_8
XFILLER_11_185 VPWR VGND sg13g2_decap_8
XFILLER_7_112 VPWR VGND sg13g2_decap_8
XFILLER_19_274 VPWR VGND sg13g2_decap_8
XFILLER_4_126 VPWR VGND sg13g2_decap_8
XFILLER_17_70 VPWR VGND sg13g2_decap_8
XFILLER_16_255 VPWR VGND sg13g2_decap_8
XFILLER_13_28 VPWR VGND sg13g2_decap_8
XFILLER_13_269 VPWR VGND sg13g2_decap_8
XFILLER_0_173 VPWR VGND sg13g2_decap_8
XFILLER_8_273 VPWR VGND sg13g2_decap_8
XFILLER_5_84 VPWR VGND sg13g2_decap_8
XFILLER_10_228 VPWR VGND sg13g2_decap_8
XFILLER_6_7 VPWR VGND sg13g2_decap_8
XFILLER_17_350 VPWR VGND sg13g2_fill_1
Xinput8 _054_/B b[0] VPWR VGND sg13g2_buf_1
XFILLER_5_210 VPWR VGND sg13g2_decap_8
XFILLER_5_265 VPWR VGND sg13g2_decap_8
XFILLER_19_49 VPWR VGND sg13g2_decap_8
XFILLER_18_147 VPWR VGND sg13g2_decap_8
XFILLER_21_28 VPWR VGND sg13g2_decap_8
XFILLER_20_312 VPWR VGND sg13g2_decap_8
XFILLER_2_63 VPWR VGND sg13g2_decap_8
XFILLER_11_345 VPWR VGND sg13g2_decap_4
XFILLER_7_338 VPWR VGND sg13g2_decap_8
X_052_ _063_/B _054_/A _054_/B VPWR VGND sg13g2_xnor2_1
XFILLER_16_28 VPWR VGND sg13g2_decap_8
XFILLER_14_161 VPWR VGND sg13g2_decap_8
Xclkbuf_1_0__f_clk _097_/CLK clkbuf_0_clk/X VPWR VGND sg13g2_buf_16
Xinput11 _090_/B b[3] VPWR VGND sg13g2_buf_1
XFILLER_20_186 VPWR VGND sg13g2_decap_8
XFILLER_21_7 VPWR VGND sg13g2_decap_8
XFILLER_19_242 VPWR VGND sg13g2_decap_4
XFILLER_11_164 VPWR VGND sg13g2_decap_8
XFILLER_8_84 VPWR VGND sg13g2_decap_8
XFILLER_4_105 VPWR VGND sg13g2_decap_8
XFILLER_16_234 VPWR VGND sg13g2_decap_8
XFILLER_0_333 VPWR VGND sg13g2_decap_8
XFILLER_4_149 VPWR VGND sg13g2_fill_1
XFILLER_13_248 VPWR VGND sg13g2_decap_8
XFILLER_0_152 VPWR VGND sg13g2_fill_2
XFILLER_10_0 VPWR VGND sg13g2_decap_8
XFILLER_8_252 VPWR VGND sg13g2_decap_8
XFILLER_5_63 VPWR VGND sg13g2_decap_8
XFILLER_10_207 VPWR VGND sg13g2_decap_8
Xinput9 _093_/B b[1] VPWR VGND sg13g2_buf_1
XFILLER_5_255 VPWR VGND sg13g2_decap_4
XFILLER_19_28 VPWR VGND sg13g2_decap_8
XFILLER_18_126 VPWR VGND sg13g2_decap_8
XFILLER_14_343 VPWR VGND sg13g2_decap_8
XFILLER_2_247 VPWR VGND sg13g2_decap_8
XFILLER_2_42 VPWR VGND sg13g2_decap_8
X_051_ _073_/A _088_/A VPWR VGND sg13g2_inv_1
XFILLER_11_324 VPWR VGND sg13g2_decap_8
XFILLER_11_84 VPWR VGND sg13g2_decap_8
XFILLER_7_317 VPWR VGND sg13g2_decap_8
Xinput12 _089_/B b[4] VPWR VGND sg13g2_buf_1
XFILLER_14_140 VPWR VGND sg13g2_decap_8
XFILLER_6_350 VPWR VGND sg13g2_fill_1
XFILLER_19_210 VPWR VGND sg13g2_decap_4
XFILLER_14_7 VPWR VGND sg13g2_decap_8
XFILLER_7_158 VPWR VGND sg13g2_decap_8
XFILLER_7_147 VPWR VGND sg13g2_decap_4
XFILLER_8_63 VPWR VGND sg13g2_decap_8
XFILLER_16_213 VPWR VGND sg13g2_decap_8
XFILLER_0_312 VPWR VGND sg13g2_decap_8
XFILLER_3_161 VPWR VGND sg13g2_decap_8
XFILLER_3_172 VPWR VGND sg13g2_fill_1
XFILLER_21_282 VPWR VGND sg13g2_decap_8
XFILLER_13_227 VPWR VGND sg13g2_decap_8
XFILLER_12_282 VPWR VGND sg13g2_decap_8
XFILLER_8_231 VPWR VGND sg13g2_decap_8
XFILLER_0_131 VPWR VGND sg13g2_decap_4
XFILLER_5_42 VPWR VGND sg13g2_decap_8
XFILLER_18_319 VPWR VGND sg13g2_decap_8
XFILLER_14_84 VPWR VGND sg13g2_decap_8
XFILLER_5_234 VPWR VGND sg13g2_decap_8
XFILLER_18_105 VPWR VGND sg13g2_decap_8
XFILLER_14_322 VPWR VGND sg13g2_decap_8
XFILLER_2_215 VPWR VGND sg13g2_decap_4
XFILLER_2_226 VPWR VGND sg13g2_decap_8
XFILLER_20_347 VPWR VGND sg13g2_decap_4
XFILLER_17_182 VPWR VGND sg13g2_decap_8
XFILLER_1_292 VPWR VGND sg13g2_decap_8
XFILLER_2_21 VPWR VGND sg13g2_decap_8
XFILLER_2_98 VPWR VGND sg13g2_decap_8
XFILLER_15_119 VPWR VGND sg13g2_decap_8
XFILLER_11_303 VPWR VGND sg13g2_decap_8
Xinput13 _074_/B b[5] VPWR VGND sg13g2_buf_1
XFILLER_14_196 VPWR VGND sg13g2_decap_8
XFILLER_11_63 VPWR VGND sg13g2_decap_8
XFILLER_20_166 VPWR VGND sg13g2_decap_4
XFILLER_20_133 VPWR VGND sg13g2_decap_4
XFILLER_11_199 VPWR VGND sg13g2_decap_8
XFILLER_11_133 VPWR VGND sg13g2_decap_8
XFILLER_7_126 VPWR VGND sg13g2_decap_8
XFILLER_0_0 VPWR VGND sg13g2_decap_8
XFILLER_3_332 VPWR VGND sg13g2_decap_8
XFILLER_19_288 VPWR VGND sg13g2_decap_8
XFILLER_8_42 VPWR VGND sg13g2_decap_8
XFILLER_17_84 VPWR VGND sg13g2_decap_8
XFILLER_16_269 VPWR VGND sg13g2_decap_8
XFILLER_15_280 VPWR VGND sg13g2_decap_8
XFILLER_21_250 VPWR VGND sg13g2_decap_8
XFILLER_12_261 VPWR VGND sg13g2_decap_8
XFILLER_8_287 VPWR VGND sg13g2_decap_8
XFILLER_0_198 VPWR VGND sg13g2_fill_1
XFILLER_0_187 VPWR VGND sg13g2_decap_8
XFILLER_0_154 VPWR VGND sg13g2_fill_1
XFILLER_5_21 VPWR VGND sg13g2_decap_8
XFILLER_5_98 VPWR VGND sg13g2_decap_8
XFILLER_14_63 VPWR VGND sg13g2_decap_8
XFILLER_5_279 VPWR VGND sg13g2_decap_8
XFILLER_4_7 VPWR VGND sg13g2_decap_8
XFILLER_17_161 VPWR VGND sg13g2_decap_8
XFILLER_14_301 VPWR VGND sg13g2_decap_8
XFILLER_2_77 VPWR VGND sg13g2_decap_8
XFILLER_20_326 VPWR VGND sg13g2_decap_8
Xinput14 _070_/B b[6] VPWR VGND sg13g2_buf_1
XFILLER_14_175 VPWR VGND sg13g2_decap_8
XFILLER_11_42 VPWR VGND sg13g2_decap_8
XFILLER_20_145 VPWR VGND sg13g2_decap_8
XFILLER_20_112 VPWR VGND sg13g2_decap_8
X_101_ _101_/Q _101_/CLK _101_/D _101__26/L_HI VPWR VGND sg13g2_dfrbpq_1
XFILLER_11_178 VPWR VGND sg13g2_decap_8
XFILLER_11_112 VPWR VGND sg13g2_decap_8
XFILLER_7_105 VPWR VGND sg13g2_decap_8
XFILLER_3_311 VPWR VGND sg13g2_decap_8
XFILLER_8_98 VPWR VGND sg13g2_decap_8
XFILLER_8_21 VPWR VGND sg13g2_decap_8
XFILLER_6_182 VPWR VGND sg13g2_decap_8
XFILLER_0_347 VPWR VGND sg13g2_decap_4
XFILLER_4_119 VPWR VGND sg13g2_decap_8
XFILLER_17_63 VPWR VGND sg13g2_decap_8
XFILLER_16_248 VPWR VGND sg13g2_decap_8
XFILLER_3_196 VPWR VGND sg13g2_decap_8
XFILLER_12_240 VPWR VGND sg13g2_decap_8
XFILLER_0_166 VPWR VGND sg13g2_decap_8
XFILLER_8_266 VPWR VGND sg13g2_decap_8
XFILLER_8_222 VPWR VGND sg13g2_decap_4
XFILLER_5_77 VPWR VGND sg13g2_decap_8
XFILLER_14_42 VPWR VGND sg13g2_decap_8
XFILLER_5_203 VPWR VGND sg13g2_decap_8
XFILLER_17_343 VPWR VGND sg13g2_decap_8
XFILLER_2_56 VPWR VGND sg13g2_decap_8
XFILLER_20_305 VPWR VGND sg13g2_decap_8
XFILLER_17_140 VPWR VGND sg13g2_decap_8
XFILLER_14_154 VPWR VGND sg13g2_decap_8
XFILLER_11_349 VPWR VGND sg13g2_fill_2
XFILLER_11_338 VPWR VGND sg13g2_decap_8
XFILLER_11_98 VPWR VGND sg13g2_decap_8
XFILLER_11_21 VPWR VGND sg13g2_decap_8
Xinput15 _088_/A rst VPWR VGND sg13g2_buf_1
XFILLER_20_179 VPWR VGND sg13g2_decap_8
X_100_ _100_/Q _101_/CLK _100_/D _100__29/L_HI VPWR VGND sg13g2_dfrbpq_1
XFILLER_11_157 VPWR VGND sg13g2_decap_8
XFILLER_19_246 VPWR VGND sg13g2_fill_1
XFILLER_8_77 VPWR VGND sg13g2_decap_8
XFILLER_6_161 VPWR VGND sg13g2_decap_8
XFILLER_19_0 VPWR VGND sg13g2_decap_8
XFILLER_0_326 VPWR VGND sg13g2_decap_8
XFILLER_17_42 VPWR VGND sg13g2_decap_8
XFILLER_16_227 VPWR VGND sg13g2_decap_8
XFILLER_12_7 VPWR VGND sg13g2_decap_8
XFILLER_21_296 VPWR VGND sg13g2_decap_8
XFILLER_0_145 VPWR VGND sg13g2_decap_8
XFILLER_0_112 VPWR VGND sg13g2_decap_8
XFILLER_12_296 VPWR VGND sg13g2_decap_8
XFILLER_8_245 VPWR VGND sg13g2_decap_8
XFILLER_8_201 VPWR VGND sg13g2_decap_8
XFILLER_5_56 VPWR VGND sg13g2_decap_8
XFILLER_14_21 VPWR VGND sg13g2_decap_8
XFILLER_17_322 VPWR VGND sg13g2_decap_8
XFILLER_14_98 VPWR VGND sg13g2_decap_8
XFILLER_5_248 VPWR VGND sg13g2_decap_8
XFILLER_5_259 VPWR VGND sg13g2_fill_2
XFILLER_18_119 VPWR VGND sg13g2_decap_8
XFILLER_14_336 VPWR VGND sg13g2_decap_8
XFILLER_17_196 VPWR VGND sg13g2_decap_8
XFILLER_9_340 VPWR VGND sg13g2_decap_8
XFILLER_2_35 VPWR VGND sg13g2_decap_8
XFILLER_11_317 VPWR VGND sg13g2_decap_8
XFILLER_11_77 VPWR VGND sg13g2_decap_8
XFILLER_14_133 VPWR VGND sg13g2_decap_8
XFILLER_6_332 VPWR VGND sg13g2_decap_8
XFILLER_19_203 VPWR VGND sg13g2_decap_8
XFILLER_19_214 VPWR VGND sg13g2_fill_1
XFILLER_11_147 VPWR VGND sg13g2_decap_4
XFILLER_8_56 VPWR VGND sg13g2_decap_8
XFILLER_3_346 VPWR VGND sg13g2_decap_4
XFILLER_18_291 VPWR VGND sg13g2_decap_8
XFILLER_6_140 VPWR VGND sg13g2_decap_8
XFILLER_17_98 VPWR VGND sg13g2_decap_8
XFILLER_17_21 VPWR VGND sg13g2_decap_8
XFILLER_16_206 VPWR VGND sg13g2_decap_8
XFILLER_0_305 VPWR VGND sg13g2_decap_8
XFILLER_3_154 VPWR VGND sg13g2_decap_8
XFILLER_15_294 VPWR VGND sg13g2_decap_8
XFILLER_21_275 VPWR VGND sg13g2_decap_8
XFILLER_21_264 VPWR VGND sg13g2_decap_8
XFILLER_13_209 VPWR VGND sg13g2_decap_8
XFILLER_0_135 VPWR VGND sg13g2_fill_2
XFILLER_12_275 VPWR VGND sg13g2_decap_8
XFILLER_5_35 VPWR VGND sg13g2_decap_8
XFILLER_17_301 VPWR VGND sg13g2_decap_8
XFILLER_14_77 VPWR VGND sg13g2_decap_8
XFILLER_4_282 VPWR VGND sg13g2_decap_8
XFILLER_14_315 VPWR VGND sg13g2_decap_8
XFILLER_2_208 VPWR VGND sg13g2_decap_8
XFILLER_2_219 VPWR VGND sg13g2_fill_2
XFILLER_17_175 VPWR VGND sg13g2_decap_8
XFILLER_9_0 VPWR VGND sg13g2_decap_8
XFILLER_1_285 VPWR VGND sg13g2_decap_8
XFILLER_1_230 VPWR VGND sg13g2_decap_8
XFILLER_2_14 VPWR VGND sg13g2_decap_8
XFILLER_11_56 VPWR VGND sg13g2_decap_8
XFILLER_2_7 VPWR VGND sg13g2_decap_8
XFILLER_14_189 VPWR VGND sg13g2_decap_8
XFILLER_14_112 VPWR VGND sg13g2_decap_8
XFILLER_6_311 VPWR VGND sg13g2_decap_8
XFILLER_20_159 VPWR VGND sg13g2_decap_8
XFILLER_20_126 VPWR VGND sg13g2_decap_8
XFILLER_9_182 VPWR VGND sg13g2_decap_8
XFILLER_11_126 VPWR VGND sg13g2_decap_8
XFILLER_7_119 VPWR VGND sg13g2_decap_8
XFILLER_3_325 VPWR VGND sg13g2_decap_8
XFILLER_18_270 VPWR VGND sg13g2_decap_8
X_089_ _089_/Y _089_/A _089_/B VPWR VGND sg13g2_nand2_1
XFILLER_8_35 VPWR VGND sg13g2_decap_8
XFILLER_6_196 VPWR VGND sg13g2_decap_8
XFILLER_17_77 VPWR VGND sg13g2_decap_8
XFILLER_15_273 VPWR VGND sg13g2_decap_8
XFILLER_3_133 VPWR VGND sg13g2_decap_4
XFILLER_21_243 VPWR VGND sg13g2_decap_8
XFILLER_0_91 VPWR VGND sg13g2_decap_8
Xclkbuf_1_1__f_clk _101_/CLK clkbuf_0_clk/X VPWR VGND sg13g2_buf_16
XFILLER_12_254 VPWR VGND sg13g2_decap_8
XFILLER_5_14 VPWR VGND sg13g2_decap_8
XFILLER_14_56 VPWR VGND sg13g2_decap_8
XFILLER_5_217 VPWR VGND sg13g2_decap_4
XFILLER_4_261 VPWR VGND sg13g2_decap_8
XFILLER_20_319 VPWR VGND sg13g2_decap_8
XFILLER_17_154 VPWR VGND sg13g2_decap_8
XFILLER_11_35 VPWR VGND sg13g2_decap_8
XFILLER_14_168 VPWR VGND sg13g2_decap_8
XFILLER_20_105 VPWR VGND sg13g2_decap_8
XFILLER_9_161 VPWR VGND sg13g2_decap_8
XFILLER_11_105 VPWR VGND sg13g2_decap_8
XFILLER_3_91 VPWR VGND sg13g2_decap_8
XFILLER_3_304 VPWR VGND sg13g2_decap_8
XFILLER_10_193 VPWR VGND sg13g2_decap_8
XFILLER_8_14 VPWR VGND sg13g2_decap_8
X_088_ _097_/D _088_/A _088_/B _088_/C VPWR VGND sg13g2_nor3_1
XFILLER_6_175 VPWR VGND sg13g2_decap_8
XFILLER_17_56 VPWR VGND sg13g2_decap_8
XFILLER_15_252 VPWR VGND sg13g2_decap_8
XFILLER_3_112 VPWR VGND sg13g2_decap_8
XFILLER_3_189 VPWR VGND sg13g2_decap_8
XFILLER_21_233 VPWR VGND sg13g2_fill_2
XFILLER_17_0 VPWR VGND sg13g2_decap_8
XFILLER_0_70 VPWR VGND sg13g2_decap_8
XFILLER_12_233 VPWR VGND sg13g2_decap_8
XFILLER_8_259 VPWR VGND sg13g2_decap_8
XFILLER_8_226 VPWR VGND sg13g2_fill_1
XFILLER_8_215 VPWR VGND sg13g2_decap_8
XFILLER_0_159 VPWR VGND sg13g2_decap_8
XFILLER_10_7 VPWR VGND sg13g2_decap_8
XFILLER_14_35 VPWR VGND sg13g2_decap_8
XFILLER_17_336 VPWR VGND sg13g2_decap_8
XFILLER_4_240 VPWR VGND sg13g2_decap_8
XFILLER_6_91 VPWR VGND sg13g2_decap_8
XFILLER_17_133 VPWR VGND sg13g2_decap_8
XFILLER_2_49 VPWR VGND sg13g2_decap_8
XFILLER_13_350 VPWR VGND sg13g2_fill_1
XFILLER_14_147 VPWR VGND sg13g2_decap_8
XFILLER_11_14 VPWR VGND sg13g2_decap_8
XFILLER_9_140 VPWR VGND sg13g2_decap_8
X_096__27 _096__27/L_HI VPWR VGND sg13g2_tiehi
XFILLER_6_346 VPWR VGND sg13g2_decap_4
XFILLER_3_70 VPWR VGND sg13g2_decap_8
XFILLER_10_172 VPWR VGND sg13g2_decap_8
X_087_ _088_/C _091_/X _087_/B _087_/C VPWR VGND sg13g2_nor3_1
XFILLER_6_154 VPWR VGND sg13g2_decap_8
XFILLER_0_319 VPWR VGND sg13g2_decap_8
XFILLER_17_35 VPWR VGND sg13g2_decap_8
XFILLER_15_220 VPWR VGND sg13g2_decap_8
XFILLER_3_168 VPWR VGND sg13g2_decap_4
XFILLER_21_212 VPWR VGND sg13g2_decap_8
XFILLER_21_289 VPWR VGND sg13g2_decap_8
XFILLER_12_212 VPWR VGND sg13g2_decap_8
XFILLER_9_91 VPWR VGND sg13g2_decap_8
XFILLER_0_105 VPWR VGND sg13g2_decap_8
XFILLER_12_289 VPWR VGND sg13g2_decap_8
XFILLER_8_238 VPWR VGND sg13g2_decap_8
XFILLER_5_49 VPWR VGND sg13g2_decap_8
XFILLER_14_14 VPWR VGND sg13g2_decap_8
XFILLER_7_282 VPWR VGND sg13g2_decap_8
XFILLER_17_315 VPWR VGND sg13g2_decap_8
XFILLER_4_296 VPWR VGND sg13g2_decap_8
XFILLER_6_70 VPWR VGND sg13g2_decap_8
XFILLER_17_112 VPWR VGND sg13g2_decap_8
XFILLER_14_329 VPWR VGND sg13g2_decap_8
XFILLER_1_244 VPWR VGND sg13g2_decap_8
XFILLER_1_299 VPWR VGND sg13g2_decap_8
XFILLER_2_28 VPWR VGND sg13g2_decap_8
XFILLER_17_189 VPWR VGND sg13g2_decap_8
XFILLER_9_333 VPWR VGND sg13g2_decap_8
XFILLER_14_126 VPWR VGND sg13g2_decap_8
X_099__25 _099__25/L_HI VPWR VGND sg13g2_tiehi
XFILLER_10_343 VPWR VGND sg13g2_decap_4
XFILLER_6_325 VPWR VGND sg13g2_decap_8
XFILLER_7_0 VPWR VGND sg13g2_decap_8
XFILLER_9_196 VPWR VGND sg13g2_decap_8
XFILLER_12_91 VPWR VGND sg13g2_decap_8
X_086_ _098_/D _088_/A _086_/B _086_/C VPWR VGND sg13g2_nor3_1
XFILLER_10_151 VPWR VGND sg13g2_decap_8
XFILLER_8_49 VPWR VGND sg13g2_decap_8
XFILLER_0_7 VPWR VGND sg13g2_decap_8
XFILLER_3_339 VPWR VGND sg13g2_decap_8
XFILLER_6_133 VPWR VGND sg13g2_decap_8
XFILLER_18_284 VPWR VGND sg13g2_decap_8
XFILLER_17_14 VPWR VGND sg13g2_decap_8
XFILLER_3_147 VPWR VGND sg13g2_decap_8
X_069_ _069_/Y _070_/A _070_/B VPWR VGND sg13g2_nand2_1
XFILLER_15_287 VPWR VGND sg13g2_decap_8
XFILLER_21_257 VPWR VGND sg13g2_decap_8
XFILLER_9_70 VPWR VGND sg13g2_decap_8
XFILLER_12_268 VPWR VGND sg13g2_decap_8
XFILLER_5_28 VPWR VGND sg13g2_decap_8
XFILLER_20_91 VPWR VGND sg13g2_decap_8
XFILLER_4_275 VPWR VGND sg13g2_decap_8
XFILLER_14_308 VPWR VGND sg13g2_decap_8
XFILLER_1_223 VPWR VGND sg13g2_decap_8
XFILLER_17_168 VPWR VGND sg13g2_decap_8
XFILLER_15_91 VPWR VGND sg13g2_decap_8
XFILLER_9_312 VPWR VGND sg13g2_decap_8
XFILLER_1_278 VPWR VGND sg13g2_decap_8
XFILLER_11_49 VPWR VGND sg13g2_decap_8
XFILLER_14_105 VPWR VGND sg13g2_decap_8
XFILLER_10_322 VPWR VGND sg13g2_decap_8
XFILLER_6_304 VPWR VGND sg13g2_decap_8
XFILLER_20_119 VPWR VGND sg13g2_decap_8
XFILLER_11_119 VPWR VGND sg13g2_decap_8
XFILLER_9_175 VPWR VGND sg13g2_decap_8
XFILLER_8_28 VPWR VGND sg13g2_decap_8
XFILLER_3_318 VPWR VGND sg13g2_decap_8
XFILLER_18_263 VPWR VGND sg13g2_decap_8
X_085_ _085_/X _089_/A _089_/B VPWR VGND sg13g2_and2_1
XFILLER_12_70 VPWR VGND sg13g2_decap_8
XFILLER_6_112 VPWR VGND sg13g2_decap_8
XFILLER_6_189 VPWR VGND sg13g2_decap_8
XFILLER_3_126 VPWR VGND sg13g2_decap_8
XFILLER_3_137 VPWR VGND sg13g2_fill_1
X_068_ _083_/B _089_/Y _065_/Y _067_/A VPWR VGND sg13g2_a21oi_1
XFILLER_15_266 VPWR VGND sg13g2_decap_8
XFILLER_0_84 VPWR VGND sg13g2_decap_8
XFILLER_20_291 VPWR VGND sg13g2_decap_8
XFILLER_12_247 VPWR VGND sg13g2_decap_8
XFILLER_18_91 VPWR VGND sg13g2_decap_8
XFILLER_15_0 VPWR VGND sg13g2_decap_8
XFILLER_14_49 VPWR VGND sg13g2_decap_8
XFILLER_20_70 VPWR VGND sg13g2_decap_8
XFILLER_16_350 VPWR VGND sg13g2_fill_1
XFILLER_4_254 VPWR VGND sg13g2_decap_8
XFILLER_17_147 VPWR VGND sg13g2_decap_8
XFILLER_15_70 VPWR VGND sg13g2_decap_8
XFILLER_1_202 VPWR VGND sg13g2_decap_8
XFILLER_11_28 VPWR VGND sg13g2_decap_8
XFILLER_10_301 VPWR VGND sg13g2_decap_8
XFILLER_13_161 VPWR VGND sg13g2_decap_8
XFILLER_9_154 VPWR VGND sg13g2_decap_8
XFILLER_3_84 VPWR VGND sg13g2_decap_8
XFILLER_18_231 VPWR VGND sg13g2_decap_8
XFILLER_19_7 VPWR VGND sg13g2_decap_8
XFILLER_10_186 VPWR VGND sg13g2_decap_8
X_084_ _086_/C _090_/X _088_/B _084_/C VPWR VGND sg13g2_nor3_1
XFILLER_2_330 VPWR VGND sg13g2_decap_8
XFILLER_6_168 VPWR VGND sg13g2_decap_8
XFILLER_17_49 VPWR VGND sg13g2_decap_8
XFILLER_3_105 VPWR VGND sg13g2_decap_8
XFILLER_21_226 VPWR VGND sg13g2_decap_8
X_067_ _082_/C _067_/A VPWR VGND sg13g2_inv_1
XFILLER_0_63 VPWR VGND sg13g2_decap_8
XFILLER_2_182 VPWR VGND sg13g2_fill_1
XFILLER_20_270 VPWR VGND sg13g2_decap_8
XFILLER_12_226 VPWR VGND sg13g2_decap_8
XFILLER_8_208 VPWR VGND sg13g2_decap_8
XFILLER_0_119 VPWR VGND sg13g2_decap_4
XFILLER_18_70 VPWR VGND sg13g2_decap_8
XFILLER_7_296 VPWR VGND sg13g2_decap_8
XFILLER_17_329 VPWR VGND sg13g2_decap_8
XFILLER_14_28 VPWR VGND sg13g2_decap_8
XFILLER_4_211 VPWR VGND sg13g2_decap_8
XFILLER_4_233 VPWR VGND sg13g2_decap_8
XFILLER_6_84 VPWR VGND sg13g2_decap_8
XFILLER_17_126 VPWR VGND sg13g2_decap_8
XFILLER_13_332 VPWR VGND sg13g2_decap_8
XFILLER_9_347 VPWR VGND sg13g2_decap_4
XFILLER_1_214 VPWR VGND sg13g2_fill_1
XFILLER_16_192 VPWR VGND sg13g2_decap_8
XFILLER_0_291 VPWR VGND sg13g2_decap_8
XFILLER_6_339 VPWR VGND sg13g2_decap_8
XFILLER_13_140 VPWR VGND sg13g2_decap_8
XFILLER_9_133 VPWR VGND sg13g2_decap_8
XFILLER_3_63 VPWR VGND sg13g2_decap_8
X_083_ _099_/D _088_/A _083_/B _083_/C VPWR VGND sg13g2_nor3_1
XFILLER_10_165 VPWR VGND sg13g2_decap_8
XFILLER_5_0 VPWR VGND sg13g2_decap_8
XFILLER_6_147 VPWR VGND sg13g2_decap_8
XFILLER_18_298 VPWR VGND sg13g2_decap_8
XFILLER_17_28 VPWR VGND sg13g2_decap_8
XFILLER_15_213 VPWR VGND sg13g2_decap_8
XFILLER_21_205 VPWR VGND sg13g2_decap_8
X_066_ _067_/A _074_/A _074_/B VPWR VGND sg13g2_xnor2_1
XFILLER_9_84 VPWR VGND sg13g2_decap_8
XFILLER_0_42 VPWR VGND sg13g2_decap_8
XFILLER_2_161 VPWR VGND sg13g2_decap_8
XFILLER_2_194 VPWR VGND sg13g2_decap_8
XFILLER_12_205 VPWR VGND sg13g2_decap_8
XFILLER_11_282 VPWR VGND sg13g2_decap_8
XFILLER_7_275 VPWR VGND sg13g2_decap_8
XFILLER_17_308 VPWR VGND sg13g2_decap_8
XFILLER_4_289 VPWR VGND sg13g2_decap_8
XFILLER_20_0 VPWR VGND sg13g2_decap_8
XFILLER_6_63 VPWR VGND sg13g2_decap_8
XFILLER_17_105 VPWR VGND sg13g2_decap_8
XFILLER_13_311 VPWR VGND sg13g2_decap_8
XFILLER_9_7 VPWR VGND sg13g2_decap_8
XFILLER_1_237 VPWR VGND sg13g2_decap_8
XFILLER_16_171 VPWR VGND sg13g2_decap_8
XFILLER_9_326 VPWR VGND sg13g2_decap_8
XFILLER_14_119 VPWR VGND sg13g2_decap_8
XFILLER_10_336 VPWR VGND sg13g2_decap_8
XFILLER_6_318 VPWR VGND sg13g2_decap_8
XFILLER_9_189 VPWR VGND sg13g2_decap_8
XFILLER_9_112 VPWR VGND sg13g2_decap_8
XFILLER_3_42 VPWR VGND sg13g2_decap_8
X_082_ _083_/C _085_/X _086_/B _082_/C VPWR VGND sg13g2_nor3_1
XFILLER_12_84 VPWR VGND sg13g2_decap_8
XFILLER_10_133 VPWR VGND sg13g2_decap_4
XFILLER_6_126 VPWR VGND sg13g2_decap_8
XFILLER_18_277 VPWR VGND sg13g2_decap_8
X_065_ _065_/Y _090_/X _088_/B _084_/C VPWR VGND sg13g2_o21ai_1
XFILLER_0_98 VPWR VGND sg13g2_decap_8
XFILLER_0_21 VPWR VGND sg13g2_decap_8
XFILLER_2_140 VPWR VGND sg13g2_decap_8
XFILLER_14_280 VPWR VGND sg13g2_decap_8
XFILLER_9_63 VPWR VGND sg13g2_decap_8
XFILLER_11_261 VPWR VGND sg13g2_decap_8
XFILLER_7_232 VPWR VGND sg13g2_decap_8
XFILLER_20_84 VPWR VGND sg13g2_decap_8
XFILLER_4_268 VPWR VGND sg13g2_decap_8
XFILLER_3_290 VPWR VGND sg13g2_decap_8
XFILLER_6_42 VPWR VGND sg13g2_decap_8
XFILLER_13_0 VPWR VGND sg13g2_decap_8
XFILLER_16_150 VPWR VGND sg13g2_decap_8
XFILLER_15_84 VPWR VGND sg13g2_decap_8
XFILLER_9_305 VPWR VGND sg13g2_decap_8
XFILLER_10_315 VPWR VGND sg13g2_decap_8
XFILLER_9_168 VPWR VGND sg13g2_decap_8
XFILLER_3_21 VPWR VGND sg13g2_decap_8
XFILLER_3_98 VPWR VGND sg13g2_decap_8
X_081_ _101_/D _069_/Y _073_/C _088_/A VPWR VGND sg13g2_a21oi_1
XFILLER_12_63 VPWR VGND sg13g2_decap_8
XFILLER_10_112 VPWR VGND sg13g2_decap_8
XFILLER_6_105 VPWR VGND sg13g2_decap_8
XFILLER_18_256 VPWR VGND sg13g2_decap_8
XFILLER_18_245 VPWR VGND sg13g2_decap_8
XFILLER_2_344 VPWR VGND sg13g2_decap_8
XFILLER_5_182 VPWR VGND sg13g2_decap_8
XFILLER_3_119 VPWR VGND sg13g2_decap_8
XFILLER_17_7 VPWR VGND sg13g2_decap_8
XFILLER_15_259 VPWR VGND sg13g2_decap_8
X_064_ _086_/B _064_/A _084_/C VPWR VGND sg13g2_nor2b_1
XFILLER_9_42 VPWR VGND sg13g2_decap_8
XFILLER_0_77 VPWR VGND sg13g2_decap_8
XFILLER_20_284 VPWR VGND sg13g2_decap_8
XFILLER_18_84 VPWR VGND sg13g2_decap_8
XFILLER_7_211 VPWR VGND sg13g2_decap_8
XFILLER_20_63 VPWR VGND sg13g2_decap_8
XFILLER_16_332 VPWR VGND sg13g2_decap_8
XFILLER_4_247 VPWR VGND sg13g2_decap_8
XFILLER_6_21 VPWR VGND sg13g2_decap_8
XFILLER_6_98 VPWR VGND sg13g2_decap_8
XFILLER_15_63 VPWR VGND sg13g2_decap_8
XFILLER_13_346 VPWR VGND sg13g2_decap_4
XFILLER_8_350 VPWR VGND sg13g2_fill_1
XFILLER_13_154 VPWR VGND sg13g2_decap_8
XFILLER_9_147 VPWR VGND sg13g2_decap_8
XFILLER_3_77 VPWR VGND sg13g2_decap_8
XFILLER_5_342 VPWR VGND sg13g2_decap_8
X_080_ _096_/D _080_/A _080_/B VPWR VGND sg13g2_and2_1
XFILLER_18_224 VPWR VGND sg13g2_decap_8
XFILLER_12_42 VPWR VGND sg13g2_decap_8
XFILLER_10_179 VPWR VGND sg13g2_decap_8
XFILLER_2_323 VPWR VGND sg13g2_decap_8
XFILLER_5_161 VPWR VGND sg13g2_decap_8
X_063_ _094_/D _088_/A _063_/B VPWR VGND sg13g2_nor2_1
XFILLER_2_175 VPWR VGND sg13g2_decap_8
XFILLER_3_0 VPWR VGND sg13g2_decap_8
XFILLER_21_219 VPWR VGND sg13g2_decap_8
XFILLER_9_98 VPWR VGND sg13g2_decap_8
XFILLER_9_21 VPWR VGND sg13g2_decap_8
XFILLER_0_56 VPWR VGND sg13g2_decap_8
XFILLER_20_263 VPWR VGND sg13g2_decap_8
XFILLER_18_63 VPWR VGND sg13g2_decap_8
XFILLER_12_219 VPWR VGND sg13g2_decap_8
XFILLER_19_330 VPWR VGND sg13g2_decap_8
XFILLER_11_296 VPWR VGND sg13g2_decap_8
XFILLER_7_289 VPWR VGND sg13g2_decap_8
XFILLER_20_42 VPWR VGND sg13g2_decap_8
XFILLER_16_311 VPWR VGND sg13g2_decap_8
XFILLER_4_204 VPWR VGND sg13g2_decap_8
XFILLER_4_226 VPWR VGND sg13g2_decap_8
XFILLER_19_182 VPWR VGND sg13g2_decap_8
XFILLER_6_77 VPWR VGND sg13g2_decap_8
XFILLER_17_119 VPWR VGND sg13g2_decap_8
XFILLER_15_42 VPWR VGND sg13g2_decap_8
XFILLER_13_325 VPWR VGND sg13g2_decap_8
XFILLER_16_185 VPWR VGND sg13g2_decap_8
XFILLER_16_130 VPWR VGND sg13g2_fill_1
XFILLER_0_284 VPWR VGND sg13g2_decap_8
.ends
