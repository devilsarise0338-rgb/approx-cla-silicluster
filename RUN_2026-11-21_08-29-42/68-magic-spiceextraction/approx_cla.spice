* NGSPICE file created from approx_cla.ext - technology: ihp-sg13g2

* Black-box entry subcircuit for sg13g2_decap_8 abstract view
.subckt sg13g2_decap_8 VDD VSS
.ends

* Black-box entry subcircuit for sg13g2_fill_2 abstract view
.subckt sg13g2_fill_2 VDD VSS
.ends

* Black-box entry subcircuit for sg13g2_dfrbpq_1 abstract view
.subckt sg13g2_dfrbpq_1 Q CLK D RESET_B VDD VSS
.ends

* Black-box entry subcircuit for sg13g2_fill_1 abstract view
.subckt sg13g2_fill_1 VDD VSS
.ends

* Black-box entry subcircuit for sg13g2_xnor2_1 abstract view
.subckt sg13g2_xnor2_1 Y A B VDD VSS
.ends

* Black-box entry subcircuit for sg13g2_nor2b_1 abstract view
.subckt sg13g2_nor2b_1 Y A B_N VDD VSS
.ends

* Black-box entry subcircuit for sg13g2_buf_1 abstract view
.subckt sg13g2_buf_1 X A VDD VSS
.ends

* Black-box entry subcircuit for sg13g2_o21ai_1 abstract view
.subckt sg13g2_o21ai_1 Y A1 A2 B1 VDD VSS
.ends

* Black-box entry subcircuit for sg13g2_nand2_1 abstract view
.subckt sg13g2_nand2_1 Y A B VDD VSS
.ends

* Black-box entry subcircuit for sg13g2_decap_4 abstract view
.subckt sg13g2_decap_4 VDD VSS
.ends

* Black-box entry subcircuit for sg13g2_inv_1 abstract view
.subckt sg13g2_inv_1 Y A VDD VSS
.ends

* Black-box entry subcircuit for sg13g2_a21oi_1 abstract view
.subckt sg13g2_a21oi_1 Y A1 A2 B1 VDD VSS
.ends

* Black-box entry subcircuit for sg13g2_tiehi abstract view
.subckt sg13g2_tiehi L_HI VDD VSS
.ends

* Black-box entry subcircuit for sg13g2_buf_16 abstract view
.subckt sg13g2_buf_16 X A VDD VSS
.ends

* Black-box entry subcircuit for sg13g2_and3_1 abstract view
.subckt sg13g2_and3_1 X A B C VDD VSS
.ends

* Black-box entry subcircuit for sg13g2_or2_1 abstract view
.subckt sg13g2_or2_1 X A B VDD VSS
.ends

* Black-box entry subcircuit for sg13g2_xor2_1 abstract view
.subckt sg13g2_xor2_1 X A B VDD VSS
.ends

.subckt approx_cla VGND VPWR a[0] a[1] a[2] a[3] a[4] a[5] a[6] b[0] b[1] b[2] b[3]
+ b[4] b[5] b[6] clk rst sum[0] sum[1] sum[2] sum[3] sum[4] sum[5] sum[6] sum[7]
XFILLER_7_7 VPWR VGND sg13g2_decap_8
XFILLER_13_133 VPWR VGND sg13g2_decap_8
XFILLER_9_126 VPWR VGND sg13g2_decap_8
XFILLER_3_56 VPWR VGND sg13g2_decap_8
XFILLER_10_147 VPWR VGND sg13g2_decap_8
XFILLER_12_21 VPWR VGND sg13g2_decap_8
XFILLER_12_98 VPWR VGND sg13g2_decap_8
XFILLER_18_258 VPWR VGND sg13g2_decap_8
XFILLER_2_324 VPWR VGND sg13g2_decap_8
XFILLER_5_140 VPWR VGND sg13g2_decap_8
XFILLER_15_228 VPWR VGND sg13g2_decap_8
XFILLER_0_35 VPWR VGND sg13g2_decap_8
XFILLER_21_209 VPWR VGND sg13g2_fill_2
XFILLER_2_154 VPWR VGND sg13g2_decap_8
XFILLER_9_77 VPWR VGND sg13g2_decap_8
XFILLER_20_231 VPWR VGND sg13g2_decap_8
X_49_ _49_/Q _55_/CLK _49_/D _49__25/L_HI VPWR VGND sg13g2_dfrbpq_1
XFILLER_11_231 VPWR VGND sg13g2_decap_8
XFILLER_18_42 VPWR VGND sg13g2_decap_8
XFILLER_7_224 VPWR VGND sg13g2_decap_8
XFILLER_20_21 VPWR VGND sg13g2_decap_8
XFILLER_20_98 VPWR VGND sg13g2_decap_8
XFILLER_19_161 VPWR VGND sg13g2_fill_2
XFILLER_6_56 VPWR VGND sg13g2_decap_8
XFILLER_3_260 VPWR VGND sg13g2_decap_8
XFILLER_13_315 VPWR VGND sg13g2_decap_8
XFILLER_15_21 VPWR VGND sg13g2_decap_8
XFILLER_15_98 VPWR VGND sg13g2_decap_8
XFILLER_9_308 VPWR VGND sg13g2_decap_8
XFILLER_0_230 VPWR VGND sg13g2_fill_2
XFILLER_0_241 VPWR VGND sg13g2_decap_8
XFILLER_11_0 VPWR VGND sg13g2_decap_8
XFILLER_13_112 VPWR VGND sg13g2_decap_8
XFILLER_13_189 VPWR VGND sg13g2_decap_8
XFILLER_9_105 VPWR VGND sg13g2_decap_8
XFILLER_5_333 VPWR VGND sg13g2_decap_8
XFILLER_3_35 VPWR VGND sg13g2_decap_8
XFILLER_8_182 VPWR VGND sg13g2_decap_8
XFILLER_10_126 VPWR VGND sg13g2_decap_8
XFILLER_12_77 VPWR VGND sg13g2_decap_8
XFILLER_18_237 VPWR VGND sg13g2_decap_8
XFILLER_2_303 VPWR VGND sg13g2_decap_8
XFILLER_6_119 VPWR VGND sg13g2_decap_8
XFILLER_5_196 VPWR VGND sg13g2_decap_8
XFILLER_15_207 VPWR VGND sg13g2_decap_8
XFILLER_0_14 VPWR VGND sg13g2_decap_8
XFILLER_14_295 VPWR VGND sg13g2_decap_8
XFILLER_2_133 VPWR VGND sg13g2_decap_8
XFILLER_2_177 VPWR VGND sg13g2_fill_1
XFILLER_9_56 VPWR VGND sg13g2_decap_8
XFILLER_20_210 VPWR VGND sg13g2_decap_8
XFILLER_20_287 VPWR VGND sg13g2_decap_8
X_48_ _48_/Y _48_/A _48_/B VPWR VGND sg13g2_xnor2_1
XFILLER_11_210 VPWR VGND sg13g2_decap_8
XFILLER_11_287 VPWR VGND sg13g2_decap_8
XFILLER_18_21 VPWR VGND sg13g2_decap_8
XFILLER_18_98 VPWR VGND sg13g2_decap_8
XFILLER_7_203 VPWR VGND sg13g2_decap_8
XFILLER_15_7 VPWR VGND sg13g2_decap_8
XFILLER_19_343 VPWR VGND sg13g2_decap_8
XFILLER_6_280 VPWR VGND sg13g2_decap_8
XFILLER_20_77 VPWR VGND sg13g2_decap_8
XFILLER_4_239 VPWR VGND sg13g2_decap_8
XFILLER_16_335 VPWR VGND sg13g2_decap_8
XFILLER_19_140 VPWR VGND sg13g2_decap_8
XFILLER_6_35 VPWR VGND sg13g2_decap_8
XFILLER_0_297 VPWR VGND sg13g2_decap_8
XFILLER_15_77 VPWR VGND sg13g2_decap_8
XFILLER_16_154 VPWR VGND sg13g2_fill_2
XFILLER_13_168 VPWR VGND sg13g2_decap_8
XFILLER_5_312 VPWR VGND sg13g2_decap_8
XFILLER_3_14 VPWR VGND sg13g2_decap_8
XFILLER_8_161 VPWR VGND sg13g2_decap_8
XFILLER_10_105 VPWR VGND sg13g2_decap_8
XFILLER_12_56 VPWR VGND sg13g2_decap_8
XFILLER_5_175 VPWR VGND sg13g2_decap_8
XFILLER_17_282 VPWR VGND sg13g2_decap_8
XFILLER_14_274 VPWR VGND sg13g2_decap_8
XFILLER_2_112 VPWR VGND sg13g2_decap_8
XFILLER_9_35 VPWR VGND sg13g2_decap_8
XFILLER_20_266 VPWR VGND sg13g2_decap_8
X_47_ _53_/D _47_/A _45_/Y VPWR VGND sg13g2_nor2b_1
XFILLER_11_266 VPWR VGND sg13g2_decap_8
XFILLER_18_77 VPWR VGND sg13g2_decap_8
XFILLER_7_259 VPWR VGND sg13g2_decap_8
XFILLER_19_322 VPWR VGND sg13g2_decap_8
XFILLER_1_0 VPWR VGND sg13g2_decap_8
XFILLER_1_91 VPWR VGND sg13g2_decap_8
XFILLER_20_56 VPWR VGND sg13g2_decap_8
XFILLER_16_314 VPWR VGND sg13g2_decap_8
XFILLER_6_14 VPWR VGND sg13g2_decap_8
XFILLER_3_295 VPWR VGND sg13g2_decap_8
XFILLER_19_163 VPWR VGND sg13g2_fill_1
XFILLER_19_196 VPWR VGND sg13g2_decap_8
XFILLER_0_232 VPWR VGND sg13g2_fill_1
XFILLER_0_276 VPWR VGND sg13g2_decap_8
XFILLER_15_56 VPWR VGND sg13g2_decap_8
XFILLER_16_133 VPWR VGND sg13g2_decap_8
XFILLER_12_350 VPWR VGND sg13g2_fill_1
XFILLER_8_343 VPWR VGND sg13g2_decap_8
XFILLER_10_309 VPWR VGND sg13g2_decap_8
XFILLER_13_147 VPWR VGND sg13g2_decap_8
XFILLER_21_191 VPWR VGND sg13g2_decap_8
XFILLER_8_140 VPWR VGND sg13g2_decap_8
XFILLER_12_35 VPWR VGND sg13g2_decap_8
XFILLER_2_338 VPWR VGND sg13g2_decap_8
XFILLER_5_7 VPWR VGND sg13g2_decap_8
XFILLER_2_349 VPWR VGND sg13g2_fill_2
XFILLER_5_154 VPWR VGND sg13g2_decap_8
XFILLER_17_261 VPWR VGND sg13g2_decap_8
X_63_ _63_/X _63_/A VPWR VGND sg13g2_buf_1
XFILLER_4_91 VPWR VGND sg13g2_decap_8
XFILLER_0_49 VPWR VGND sg13g2_decap_8
XFILLER_2_168 VPWR VGND sg13g2_decap_8
XFILLER_14_253 VPWR VGND sg13g2_decap_8
X_46_ _47_/A _45_/A _45_/B _52_/D VPWR VGND sg13g2_o21ai_1
XFILLER_9_14 VPWR VGND sg13g2_decap_8
XFILLER_18_56 VPWR VGND sg13g2_decap_8
XFILLER_20_245 VPWR VGND sg13g2_decap_8
XFILLER_11_245 VPWR VGND sg13g2_decap_8
XFILLER_19_301 VPWR VGND sg13g2_decap_8
XFILLER_7_238 VPWR VGND sg13g2_decap_8
XFILLER_1_70 VPWR VGND sg13g2_decap_8
X_29_ _29_/Y _40_/A _40_/B VPWR VGND sg13g2_nand2_1
XFILLER_20_35 VPWR VGND sg13g2_decap_8
XFILLER_19_175 VPWR VGND sg13g2_decap_8
XFILLER_20_7 VPWR VGND sg13g2_decap_8
XFILLER_3_274 VPWR VGND sg13g2_decap_8
XFILLER_0_255 VPWR VGND sg13g2_decap_8
XFILLER_13_329 VPWR VGND sg13g2_decap_8
XFILLER_15_35 VPWR VGND sg13g2_decap_8
Xoutput12 sum[0] _63_/A VPWR VGND sg13g2_buf_1
XFILLER_16_112 VPWR VGND sg13g2_decap_8
XFILLER_16_156 VPWR VGND sg13g2_fill_1
XFILLER_16_189 VPWR VGND sg13g2_decap_8
XFILLER_8_322 VPWR VGND sg13g2_decap_8
XFILLER_7_91 VPWR VGND sg13g2_decap_8
XFILLER_13_126 VPWR VGND sg13g2_decap_8
XFILLER_9_119 VPWR VGND sg13g2_decap_8
XFILLER_5_347 VPWR VGND sg13g2_decap_4
XFILLER_3_49 VPWR VGND sg13g2_decap_8
XFILLER_12_14 VPWR VGND sg13g2_decap_8
XFILLER_8_196 VPWR VGND sg13g2_decap_8
XFILLER_2_317 VPWR VGND sg13g2_decap_8
XFILLER_5_133 VPWR VGND sg13g2_decap_8
XFILLER_1_350 VPWR VGND sg13g2_fill_1
XFILLER_2_147 VPWR VGND sg13g2_decap_8
XFILLER_4_70 VPWR VGND sg13g2_decap_8
XFILLER_0_28 VPWR VGND sg13g2_decap_8
XFILLER_14_232 VPWR VGND sg13g2_decap_8
XFILLER_18_35 VPWR VGND sg13g2_decap_8
XFILLER_20_224 VPWR VGND sg13g2_decap_8
XFILLER_9_280 VPWR VGND sg13g2_decap_8
X_45_ _45_/Y _45_/A _45_/B VPWR VGND sg13g2_nand2_1
XFILLER_11_224 VPWR VGND sg13g2_decap_8
Xclkload0 clkload0/Y _55_/CLK VPWR VGND sg13g2_inv_1
XFILLER_7_217 VPWR VGND sg13g2_decap_8
X_28_ _52_/D _28_/A VPWR VGND sg13g2_inv_1
XFILLER_6_294 VPWR VGND sg13g2_decap_8
XFILLER_20_14 VPWR VGND sg13g2_decap_8
XFILLER_4_209 VPWR VGND sg13g2_fill_2
XFILLER_10_91 VPWR VGND sg13g2_decap_8
XFILLER_13_7 VPWR VGND sg13g2_decap_8
XFILLER_19_154 VPWR VGND sg13g2_decap_8
XFILLER_3_220 VPWR VGND sg13g2_decap_8
XFILLER_6_49 VPWR VGND sg13g2_decap_8
XFILLER_3_253 VPWR VGND sg13g2_decap_8
XFILLER_0_201 VPWR VGND sg13g2_decap_4
XFILLER_13_308 VPWR VGND sg13g2_decap_8
XFILLER_15_14 VPWR VGND sg13g2_decap_8
Xoutput13 sum[1] _63_/X VPWR VGND sg13g2_buf_1
XFILLER_0_223 VPWR VGND sg13g2_decap_8
XFILLER_8_301 VPWR VGND sg13g2_decap_8
XFILLER_7_70 VPWR VGND sg13g2_decap_8
XFILLER_13_105 VPWR VGND sg13g2_decap_8
XFILLER_5_326 VPWR VGND sg13g2_decap_8
XFILLER_3_28 VPWR VGND sg13g2_decap_8
XFILLER_12_182 VPWR VGND sg13g2_decap_8
XFILLER_8_175 VPWR VGND sg13g2_decap_8
XFILLER_10_119 VPWR VGND sg13g2_decap_8
XFILLER_17_296 VPWR VGND sg13g2_decap_8
XFILLER_5_189 VPWR VGND sg13g2_decap_8
XFILLER_5_112 VPWR VGND sg13g2_decap_8
XFILLER_13_91 VPWR VGND sg13g2_decap_8
XFILLER_14_288 VPWR VGND sg13g2_decap_8
XFILLER_2_126 VPWR VGND sg13g2_decap_8
XFILLER_9_49 VPWR VGND sg13g2_decap_8
XFILLER_20_203 VPWR VGND sg13g2_decap_8
X_44_ _49_/D _40_/Y _42_/Y _43_/Y VPWR VGND sg13g2_a21oi_1
XFILLER_11_203 VPWR VGND sg13g2_decap_8
XFILLER_18_14 VPWR VGND sg13g2_decap_8
XFILLER_19_336 VPWR VGND sg13g2_decap_8
XFILLER_6_273 VPWR VGND sg13g2_decap_8
XFILLER_16_328 VPWR VGND sg13g2_decap_8
XFILLER_10_70 VPWR VGND sg13g2_decap_8
XFILLER_19_133 VPWR VGND sg13g2_decap_8
XFILLER_6_28 VPWR VGND sg13g2_decap_8
XFILLER_21_342 VPWR VGND sg13g2_decap_8
XFILLER_16_147 VPWR VGND sg13g2_decap_8
XFILLER_21_91 VPWR VGND sg13g2_decap_8
Xoutput14 sum[2] _53_/Q VPWR VGND sg13g2_buf_1
XFILLER_5_305 VPWR VGND sg13g2_decap_8
XFILLER_12_161 VPWR VGND sg13g2_decap_8
XFILLER_16_91 VPWR VGND sg13g2_decap_8
XFILLER_8_154 VPWR VGND sg13g2_decap_8
XFILLER_12_49 VPWR VGND sg13g2_decap_8
XFILLER_18_209 VPWR VGND sg13g2_fill_2
XFILLER_17_231 VPWR VGND sg13g2_decap_8
XFILLER_17_275 VPWR VGND sg13g2_decap_8
XFILLER_5_168 VPWR VGND sg13g2_decap_8
XFILLER_13_70 VPWR VGND sg13g2_decap_8
XFILLER_14_267 VPWR VGND sg13g2_decap_8
XFILLER_2_105 VPWR VGND sg13g2_decap_8
XFILLER_9_28 VPWR VGND sg13g2_decap_8
XFILLER_3_7 VPWR VGND sg13g2_decap_8
XFILLER_1_182 VPWR VGND sg13g2_decap_8
XFILLER_20_259 VPWR VGND sg13g2_decap_8
X_43_ _43_/Y _40_/Y _42_/Y _52_/D VPWR VGND sg13g2_o21ai_1
XFILLER_11_259 VPWR VGND sg13g2_decap_8
XFILLER_10_281 VPWR VGND sg13g2_decap_8
XFILLER_19_315 VPWR VGND sg13g2_decap_8
XFILLER_6_252 VPWR VGND sg13g2_decap_8
XFILLER_1_84 VPWR VGND sg13g2_decap_8
XFILLER_20_49 VPWR VGND sg13g2_decap_8
XFILLER_16_307 VPWR VGND sg13g2_decap_8
XFILLER_19_112 VPWR VGND sg13g2_decap_8
XFILLER_19_189 VPWR VGND sg13g2_decap_8
XFILLER_19_91 VPWR VGND sg13g2_decap_8
XFILLER_3_288 VPWR VGND sg13g2_decap_8
XFILLER_15_49 VPWR VGND sg13g2_decap_8
XFILLER_21_321 VPWR VGND sg13g2_decap_8
XFILLER_0_269 VPWR VGND sg13g2_decap_8
XFILLER_12_343 VPWR VGND sg13g2_decap_8
XFILLER_16_126 VPWR VGND sg13g2_decap_8
Xoutput15 sum[3] _54_/Q VPWR VGND sg13g2_buf_1
XFILLER_8_336 VPWR VGND sg13g2_decap_8
XFILLER_21_70 VPWR VGND sg13g2_decap_8
XFILLER_21_140 VPWR VGND sg13g2_decap_8
XFILLER_21_151 VPWR VGND sg13g2_fill_2
XFILLER_12_140 VPWR VGND sg13g2_decap_8
XFILLER_16_70 VPWR VGND sg13g2_decap_8
XFILLER_8_133 VPWR VGND sg13g2_decap_8
XFILLER_12_28 VPWR VGND sg13g2_decap_8
XFILLER_5_147 VPWR VGND sg13g2_decap_8
XFILLER_17_254 VPWR VGND sg13g2_decap_8
XFILLER_4_84 VPWR VGND sg13g2_decap_8
XFILLER_14_246 VPWR VGND sg13g2_decap_8
XFILLER_1_161 VPWR VGND sg13g2_decap_8
XFILLER_20_238 VPWR VGND sg13g2_decap_8
X_42_ _42_/Y _42_/A _42_/B VPWR VGND sg13g2_nand2_1
X_50__26 _50__26/L_HI VPWR VGND sg13g2_tiehi
XFILLER_11_238 VPWR VGND sg13g2_decap_8
XFILLER_18_49 VPWR VGND sg13g2_decap_8
XFILLER_9_294 VPWR VGND sg13g2_decap_8
XFILLER_10_260 VPWR VGND sg13g2_decap_8
XFILLER_1_63 VPWR VGND sg13g2_decap_8
XFILLER_20_28 VPWR VGND sg13g2_decap_8
XFILLER_3_234 VPWR VGND sg13g2_fill_1
XFILLER_3_267 VPWR VGND sg13g2_decap_8
XFILLER_18_0 VPWR VGND sg13g2_decap_8
XFILLER_19_168 VPWR VGND sg13g2_decap_8
XFILLER_19_70 VPWR VGND sg13g2_decap_8
XFILLER_0_248 VPWR VGND sg13g2_decap_8
XFILLER_15_28 VPWR VGND sg13g2_decap_8
XFILLER_16_105 VPWR VGND sg13g2_decap_8
XFILLER_21_300 VPWR VGND sg13g2_decap_8
Xoutput16 sum[4] _55_/Q VPWR VGND sg13g2_buf_1
XFILLER_11_7 VPWR VGND sg13g2_decap_8
XFILLER_12_322 VPWR VGND sg13g2_decap_8
XFILLER_15_193 VPWR VGND sg13g2_decap_8
Xclkbuf_0_clk clkbuf_0_clk/X clk VPWR VGND sg13g2_buf_16
XFILLER_8_315 VPWR VGND sg13g2_decap_8
XFILLER_13_119 VPWR VGND sg13g2_decap_8
XFILLER_7_84 VPWR VGND sg13g2_decap_8
XFILLER_12_196 VPWR VGND sg13g2_decap_8
XFILLER_8_189 VPWR VGND sg13g2_decap_8
XFILLER_8_112 VPWR VGND sg13g2_decap_8
XFILLER_1_343 VPWR VGND sg13g2_decap_8
XFILLER_5_126 VPWR VGND sg13g2_decap_8
X_53__24 _53__24/L_HI VPWR VGND sg13g2_tiehi
XFILLER_4_63 VPWR VGND sg13g2_decap_8
XFILLER_4_192 VPWR VGND sg13g2_decap_4
XFILLER_14_203 VPWR VGND sg13g2_fill_1
XFILLER_1_140 VPWR VGND sg13g2_decap_8
X_41_ _55_/D _41_/A _42_/Y VPWR VGND sg13g2_nor2b_1
XFILLER_11_217 VPWR VGND sg13g2_decap_8
XFILLER_13_280 VPWR VGND sg13g2_decap_8
XFILLER_18_28 VPWR VGND sg13g2_decap_8
XFILLER_20_217 VPWR VGND sg13g2_decap_8
XFILLER_9_273 VPWR VGND sg13g2_decap_8
XFILLER_6_210 VPWR VGND sg13g2_decap_8
XFILLER_1_42 VPWR VGND sg13g2_decap_8
XFILLER_6_287 VPWR VGND sg13g2_decap_8
XFILLER_3_246 VPWR VGND sg13g2_decap_8
XFILLER_10_84 VPWR VGND sg13g2_decap_8
XFILLER_15_342 VPWR VGND sg13g2_decap_8
XFILLER_19_147 VPWR VGND sg13g2_decap_8
XFILLER_0_216 VPWR VGND sg13g2_fill_2
Xoutput17 sum[5] _49_/Q VPWR VGND sg13g2_buf_1
XFILLER_12_301 VPWR VGND sg13g2_decap_8
XFILLER_15_161 VPWR VGND sg13g2_decap_4
XFILLER_15_172 VPWR VGND sg13g2_decap_8
XFILLER_7_63 VPWR VGND sg13g2_decap_8
XFILLER_5_319 VPWR VGND sg13g2_decap_8
XFILLER_12_175 VPWR VGND sg13g2_decap_8
XFILLER_8_168 VPWR VGND sg13g2_decap_8
XFILLER_4_330 VPWR VGND sg13g2_decap_8
XFILLER_5_105 VPWR VGND sg13g2_decap_8
XFILLER_17_212 VPWR VGND sg13g2_decap_8
XFILLER_17_289 VPWR VGND sg13g2_decap_8
XFILLER_1_322 VPWR VGND sg13g2_decap_8
XFILLER_4_42 VPWR VGND sg13g2_decap_8
XFILLER_2_119 VPWR VGND sg13g2_decap_8
XFILLER_13_84 VPWR VGND sg13g2_decap_8
XFILLER_1_196 VPWR VGND sg13g2_decap_8
X_40_ _40_/Y _40_/A _40_/B VPWR VGND sg13g2_xnor2_1
XFILLER_8_0 VPWR VGND sg13g2_decap_8
XFILLER_9_252 VPWR VGND sg13g2_decap_8
XFILLER_19_329 VPWR VGND sg13g2_decap_8
XFILLER_1_7 VPWR VGND sg13g2_decap_8
XFILLER_10_295 VPWR VGND sg13g2_decap_8
XFILLER_1_21 VPWR VGND sg13g2_decap_8
XFILLER_1_98 VPWR VGND sg13g2_decap_8
XFILLER_6_266 VPWR VGND sg13g2_decap_8
XFILLER_10_63 VPWR VGND sg13g2_decap_8
XFILLER_15_321 VPWR VGND sg13g2_decap_8
XFILLER_19_126 VPWR VGND sg13g2_decap_8
XFILLER_18_181 VPWR VGND sg13g2_decap_8
XFILLER_21_335 VPWR VGND sg13g2_decap_8
Xoutput18 sum[6] _50_/Q VPWR VGND sg13g2_buf_1
XFILLER_21_84 VPWR VGND sg13g2_decap_8
XFILLER_15_140 VPWR VGND sg13g2_decap_8
XFILLER_7_42 VPWR VGND sg13g2_decap_8
XFILLER_7_350 VPWR VGND sg13g2_fill_1
XFILLER_21_176 VPWR VGND sg13g2_decap_8
XFILLER_21_198 VPWR VGND sg13g2_decap_8
XFILLER_12_154 VPWR VGND sg13g2_decap_8
XFILLER_16_84 VPWR VGND sg13g2_decap_8
XFILLER_8_147 VPWR VGND sg13g2_decap_8
XFILLER_17_224 VPWR VGND sg13g2_decap_8
XFILLER_17_268 VPWR VGND sg13g2_decap_8
XFILLER_1_301 VPWR VGND sg13g2_decap_8
XFILLER_4_98 VPWR VGND sg13g2_decap_8
XFILLER_4_21 VPWR VGND sg13g2_decap_8
XFILLER_4_172 VPWR VGND sg13g2_fill_1
XFILLER_4_161 VPWR VGND sg13g2_decap_8
XFILLER_13_63 VPWR VGND sg13g2_decap_8
XFILLER_1_175 VPWR VGND sg13g2_decap_8
XFILLER_9_231 VPWR VGND sg13g2_decap_8
XFILLER_19_308 VPWR VGND sg13g2_decap_8
XFILLER_10_274 VPWR VGND sg13g2_decap_8
XFILLER_1_77 VPWR VGND sg13g2_decap_8
XFILLER_6_245 VPWR VGND sg13g2_decap_8
XFILLER_10_42 VPWR VGND sg13g2_decap_8
XFILLER_15_300 VPWR VGND sg13g2_decap_8
XFILLER_19_105 VPWR VGND sg13g2_decap_8
XFILLER_19_84 VPWR VGND sg13g2_decap_8
XFILLER_18_171 VPWR VGND sg13g2_fill_1
XFILLER_21_314 VPWR VGND sg13g2_decap_8
XFILLER_0_218 VPWR VGND sg13g2_fill_1
XFILLER_12_336 VPWR VGND sg13g2_decap_8
XFILLER_16_119 VPWR VGND sg13g2_decap_8
XFILLER_21_63 VPWR VGND sg13g2_decap_8
Xoutput19 sum[7] _51_/Q VPWR VGND sg13g2_buf_1
XFILLER_8_329 VPWR VGND sg13g2_decap_8
XFILLER_7_98 VPWR VGND sg13g2_decap_8
XFILLER_7_21 VPWR VGND sg13g2_decap_8
XFILLER_16_0 VPWR VGND sg13g2_decap_8
XFILLER_21_133 VPWR VGND sg13g2_decap_8
XFILLER_12_133 VPWR VGND sg13g2_decap_8
XFILLER_16_63 VPWR VGND sg13g2_decap_8
XFILLER_8_126 VPWR VGND sg13g2_decap_8
XFILLER_17_247 VPWR VGND sg13g2_decap_8
XFILLER_4_77 VPWR VGND sg13g2_decap_8
XFILLER_4_140 VPWR VGND sg13g2_decap_8
XFILLER_13_42 VPWR VGND sg13g2_decap_8
XFILLER_14_239 VPWR VGND sg13g2_decap_8
XFILLER_13_294 VPWR VGND sg13g2_decap_8
XFILLER_1_154 VPWR VGND sg13g2_decap_8
XFILLER_9_210 VPWR VGND sg13g2_decap_8
XFILLER_9_287 VPWR VGND sg13g2_decap_8
XFILLER_10_253 VPWR VGND sg13g2_decap_8
XFILLER_18_342 VPWR VGND sg13g2_decap_8
XFILLER_1_56 VPWR VGND sg13g2_decap_8
XFILLER_10_21 VPWR VGND sg13g2_decap_8
XFILLER_10_98 VPWR VGND sg13g2_decap_8
XFILLER_19_63 VPWR VGND sg13g2_decap_8
XFILLER_3_227 VPWR VGND sg13g2_decap_8
XFILLER_2_282 VPWR VGND sg13g2_decap_8
XFILLER_12_315 VPWR VGND sg13g2_decap_8
XFILLER_8_308 VPWR VGND sg13g2_decap_8
XFILLER_15_186 VPWR VGND sg13g2_decap_8
XFILLER_21_42 VPWR VGND sg13g2_decap_8
XFILLER_7_77 VPWR VGND sg13g2_decap_8
XFILLER_21_112 VPWR VGND sg13g2_decap_8
XFILLER_12_112 VPWR VGND sg13g2_decap_8
XFILLER_12_189 VPWR VGND sg13g2_decap_8
XFILLER_16_42 VPWR VGND sg13g2_decap_8
XFILLER_8_105 VPWR VGND sg13g2_decap_8
XFILLER_4_344 VPWR VGND sg13g2_decap_8
XFILLER_7_182 VPWR VGND sg13g2_decap_8
XFILLER_1_336 VPWR VGND sg13g2_decap_8
XFILLER_5_119 VPWR VGND sg13g2_decap_8
XFILLER_4_56 VPWR VGND sg13g2_decap_8
XFILLER_4_196 VPWR VGND sg13g2_fill_2
XFILLER_13_21 VPWR VGND sg13g2_decap_8
XFILLER_13_273 VPWR VGND sg13g2_decap_8
XFILLER_13_98 VPWR VGND sg13g2_decap_8
XFILLER_1_133 VPWR VGND sg13g2_decap_8
XFILLER_9_266 VPWR VGND sg13g2_decap_8
XFILLER_10_210 VPWR VGND sg13g2_decap_4
XFILLER_6_203 VPWR VGND sg13g2_decap_8
XFILLER_6_0 VPWR VGND sg13g2_decap_8
XFILLER_18_321 VPWR VGND sg13g2_decap_8
XFILLER_1_35 VPWR VGND sg13g2_decap_8
XFILLER_5_291 VPWR VGND sg13g2_decap_8
XFILLER_10_77 VPWR VGND sg13g2_decap_8
XFILLER_19_42 VPWR VGND sg13g2_decap_8
XFILLER_3_239 VPWR VGND sg13g2_decap_8
Xinput1 _45_/A a[2] VPWR VGND sg13g2_buf_1
XFILLER_15_335 VPWR VGND sg13g2_decap_8
XFILLER_18_140 VPWR VGND sg13g2_decap_8
XFILLER_18_151 VPWR VGND sg13g2_fill_2
XFILLER_2_261 VPWR VGND sg13g2_decap_8
XFILLER_0_209 VPWR VGND sg13g2_decap_8
XFILLER_18_195 VPWR VGND sg13g2_decap_8
XFILLER_21_349 VPWR VGND sg13g2_fill_2
XFILLER_15_154 VPWR VGND sg13g2_decap_8
XFILLER_15_165 VPWR VGND sg13g2_fill_2
XFILLER_21_21 VPWR VGND sg13g2_decap_8
XFILLER_21_98 VPWR VGND sg13g2_decap_8
XFILLER_7_56 VPWR VGND sg13g2_decap_8
XFILLER_12_168 VPWR VGND sg13g2_decap_8
XFILLER_16_21 VPWR VGND sg13g2_decap_8
XFILLER_16_98 VPWR VGND sg13g2_decap_8
XFILLER_4_323 VPWR VGND sg13g2_decap_8
XFILLER_7_161 VPWR VGND sg13g2_decap_8
XFILLER_1_315 VPWR VGND sg13g2_decap_8
XFILLER_21_0 VPWR VGND sg13g2_decap_8
XFILLER_17_205 VPWR VGND sg13g2_decap_4
XFILLER_17_238 VPWR VGND sg13g2_fill_1
XFILLER_4_35 VPWR VGND sg13g2_decap_8
XFILLER_16_293 VPWR VGND sg13g2_decap_8
XFILLER_13_77 VPWR VGND sg13g2_decap_8
XFILLER_1_112 VPWR VGND sg13g2_decap_8
XFILLER_1_189 VPWR VGND sg13g2_decap_8
XFILLER_13_252 VPWR VGND sg13g2_decap_8
XFILLER_9_245 VPWR VGND sg13g2_decap_8
XFILLER_10_288 VPWR VGND sg13g2_decap_8
XFILLER_18_300 VPWR VGND sg13g2_decap_8
XFILLER_1_14 VPWR VGND sg13g2_decap_8
XFILLER_6_259 VPWR VGND sg13g2_decap_8
XFILLER_10_56 VPWR VGND sg13g2_decap_8
Xinput2 _48_/A a[3] VPWR VGND sg13g2_buf_1
XFILLER_5_270 VPWR VGND sg13g2_decap_8
XFILLER_15_314 VPWR VGND sg13g2_decap_8
XFILLER_19_119 VPWR VGND sg13g2_decap_8
XFILLER_19_21 VPWR VGND sg13g2_decap_8
XFILLER_19_98 VPWR VGND sg13g2_decap_8
XFILLER_2_240 VPWR VGND sg13g2_decap_8
XFILLER_21_328 VPWR VGND sg13g2_decap_8
XFILLER_20_350 VPWR VGND sg13g2_fill_1
XFILLER_21_77 VPWR VGND sg13g2_decap_8
XFILLER_11_350 VPWR VGND sg13g2_fill_1
XFILLER_15_133 VPWR VGND sg13g2_decap_8
XFILLER_7_35 VPWR VGND sg13g2_decap_8
XFILLER_7_343 VPWR VGND sg13g2_decap_8
XFILLER_12_147 VPWR VGND sg13g2_decap_8
XFILLER_16_77 VPWR VGND sg13g2_decap_8
XFILLER_21_147 VPWR VGND sg13g2_decap_4
XFILLER_21_169 VPWR VGND sg13g2_decap_8
XFILLER_7_140 VPWR VGND sg13g2_decap_8
XFILLER_4_302 VPWR VGND sg13g2_decap_8
XFILLER_14_0 VPWR VGND sg13g2_decap_8
XFILLER_19_280 VPWR VGND sg13g2_decap_8
XFILLER_4_154 VPWR VGND sg13g2_decap_8
XFILLER_4_14 VPWR VGND sg13g2_decap_8
XFILLER_16_272 VPWR VGND sg13g2_decap_8
XFILLER_13_56 VPWR VGND sg13g2_decap_8
XFILLER_1_168 VPWR VGND sg13g2_decap_8
XFILLER_13_231 VPWR VGND sg13g2_decap_8
XFILLER_9_224 VPWR VGND sg13g2_decap_8
XFILLER_10_267 VPWR VGND sg13g2_decap_8
Xinput3 _42_/A a[4] VPWR VGND sg13g2_buf_1
XFILLER_10_35 VPWR VGND sg13g2_decap_8
XFILLER_19_77 VPWR VGND sg13g2_decap_8
XFILLER_18_7 VPWR VGND sg13g2_decap_8
XFILLER_21_307 VPWR VGND sg13g2_decap_8
XFILLER_2_296 VPWR VGND sg13g2_decap_8
XFILLER_12_329 VPWR VGND sg13g2_decap_8
XFILLER_21_56 VPWR VGND sg13g2_decap_8
XFILLER_2_91 VPWR VGND sg13g2_decap_8
XFILLER_15_112 VPWR VGND sg13g2_decap_8
XFILLER_7_322 VPWR VGND sg13g2_decap_8
XFILLER_7_14 VPWR VGND sg13g2_decap_8
XFILLER_21_126 VPWR VGND sg13g2_decap_8
XFILLER_12_126 VPWR VGND sg13g2_decap_8
XFILLER_16_56 VPWR VGND sg13g2_decap_8
XFILLER_8_119 VPWR VGND sg13g2_decap_8
XFILLER_7_196 VPWR VGND sg13g2_decap_8
XFILLER_0_350 VPWR VGND sg13g2_fill_1
XFILLER_4_133 VPWR VGND sg13g2_decap_8
XFILLER_13_35 VPWR VGND sg13g2_decap_8
XFILLER_1_147 VPWR VGND sg13g2_decap_8
XFILLER_13_210 VPWR VGND sg13g2_decap_8
XFILLER_13_287 VPWR VGND sg13g2_decap_8
XFILLER_9_203 VPWR VGND sg13g2_decap_8
XFILLER_8_280 VPWR VGND sg13g2_decap_8
XFILLER_5_91 VPWR VGND sg13g2_decap_8
XFILLER_10_246 VPWR VGND sg13g2_decap_8
XFILLER_18_335 VPWR VGND sg13g2_decap_8
XFILLER_1_49 VPWR VGND sg13g2_decap_8
XFILLER_6_217 VPWR VGND sg13g2_fill_2
Xinput4 _40_/A a[5] VPWR VGND sg13g2_buf_1
XFILLER_10_14 VPWR VGND sg13g2_decap_8
XFILLER_15_349 VPWR VGND sg13g2_fill_2
XFILLER_19_56 VPWR VGND sg13g2_decap_8
XFILLER_18_165 VPWR VGND sg13g2_fill_1
XFILLER_2_275 VPWR VGND sg13g2_decap_8
XFILLER_4_0 VPWR VGND sg13g2_decap_8
XFILLER_12_308 VPWR VGND sg13g2_decap_8
XFILLER_21_35 VPWR VGND sg13g2_decap_8
XFILLER_2_70 VPWR VGND sg13g2_decap_8
XFILLER_15_179 VPWR VGND sg13g2_decap_8
XFILLER_7_301 VPWR VGND sg13g2_decap_8
XFILLER_21_105 VPWR VGND sg13g2_decap_8
XFILLER_12_105 VPWR VGND sg13g2_decap_8
XFILLER_16_35 VPWR VGND sg13g2_decap_8
XFILLER_20_182 VPWR VGND sg13g2_decap_8
XFILLER_4_337 VPWR VGND sg13g2_decap_8
XFILLER_11_182 VPWR VGND sg13g2_decap_8
XFILLER_7_175 VPWR VGND sg13g2_decap_8
XFILLER_1_329 VPWR VGND sg13g2_decap_8
XFILLER_8_91 VPWR VGND sg13g2_decap_8
XFILLER_16_230 VPWR VGND sg13g2_decap_8
XFILLER_4_49 VPWR VGND sg13g2_decap_8
XFILLER_4_112 VPWR VGND sg13g2_decap_8
XFILLER_13_14 VPWR VGND sg13g2_decap_8
X_52__21 _52__21/L_HI VPWR VGND sg13g2_tiehi
XFILLER_13_266 VPWR VGND sg13g2_decap_8
XFILLER_1_126 VPWR VGND sg13g2_decap_8
XFILLER_9_259 VPWR VGND sg13g2_decap_8
XFILLER_8_7 VPWR VGND sg13g2_decap_8
XFILLER_0_170 VPWR VGND sg13g2_fill_1
XFILLER_5_70 VPWR VGND sg13g2_decap_8
XFILLER_10_203 VPWR VGND sg13g2_decap_8
XFILLER_1_28 VPWR VGND sg13g2_decap_8
XFILLER_18_314 VPWR VGND sg13g2_decap_8
Xinput5 _34_/A a[6] VPWR VGND sg13g2_buf_1
XFILLER_5_284 VPWR VGND sg13g2_decap_8
XFILLER_15_328 VPWR VGND sg13g2_decap_8
XFILLER_19_35 VPWR VGND sg13g2_decap_8
XFILLER_18_133 VPWR VGND sg13g2_decap_8
XFILLER_18_188 VPWR VGND sg13g2_decap_8
XFILLER_2_254 VPWR VGND sg13g2_decap_8
XFILLER_15_147 VPWR VGND sg13g2_decap_8
XFILLER_21_14 VPWR VGND sg13g2_decap_8
XFILLER_7_49 VPWR VGND sg13g2_decap_8
XFILLER_11_91 VPWR VGND sg13g2_decap_8
XFILLER_16_14 VPWR VGND sg13g2_decap_8
XFILLER_20_161 VPWR VGND sg13g2_decap_8
XFILLER_4_316 VPWR VGND sg13g2_decap_8
XFILLER_11_161 VPWR VGND sg13g2_decap_8
XFILLER_7_154 VPWR VGND sg13g2_decap_8
XFILLER_19_294 VPWR VGND sg13g2_decap_8
XFILLER_1_308 VPWR VGND sg13g2_decap_8
XFILLER_8_70 VPWR VGND sg13g2_decap_8
XFILLER_4_28 VPWR VGND sg13g2_decap_8
XFILLER_4_168 VPWR VGND sg13g2_decap_4
XFILLER_12_0 VPWR VGND sg13g2_decap_8
XFILLER_16_286 VPWR VGND sg13g2_decap_8
XFILLER_3_190 VPWR VGND sg13g2_fill_2
XFILLER_13_245 VPWR VGND sg13g2_decap_8
XFILLER_1_105 VPWR VGND sg13g2_decap_8
XFILLER_9_238 VPWR VGND sg13g2_decap_8
XFILLER_6_219 VPWR VGND sg13g2_fill_1
XFILLER_14_91 VPWR VGND sg13g2_decap_8
XFILLER_5_263 VPWR VGND sg13g2_decap_8
XFILLER_10_49 VPWR VGND sg13g2_decap_8
XFILLER_19_14 VPWR VGND sg13g2_decap_8
Xinput6 _45_/B b[2] VPWR VGND sg13g2_buf_1
XFILLER_15_307 VPWR VGND sg13g2_decap_8
XFILLER_18_112 VPWR VGND sg13g2_decap_8
XFILLER_2_233 VPWR VGND sg13g2_decap_8
XFILLER_15_126 VPWR VGND sg13g2_decap_8
XFILLER_20_343 VPWR VGND sg13g2_decap_8
XFILLER_11_343 VPWR VGND sg13g2_decap_8
XFILLER_11_70 VPWR VGND sg13g2_decap_8
XFILLER_16_7 VPWR VGND sg13g2_decap_8
XFILLER_7_336 VPWR VGND sg13g2_decap_8
XFILLER_7_28 VPWR VGND sg13g2_decap_8
XFILLER_20_140 VPWR VGND sg13g2_decap_8
XFILLER_11_140 VPWR VGND sg13g2_decap_8
XFILLER_7_133 VPWR VGND sg13g2_decap_8
XFILLER_19_273 VPWR VGND sg13g2_decap_8
XFILLER_4_147 VPWR VGND sg13g2_decap_8
XFILLER_16_265 VPWR VGND sg13g2_decap_8
XFILLER_17_91 VPWR VGND sg13g2_decap_8
XFILLER_3_180 VPWR VGND sg13g2_fill_1
XFILLER_13_224 VPWR VGND sg13g2_decap_8
XFILLER_13_49 VPWR VGND sg13g2_decap_8
XFILLER_0_161 VPWR VGND sg13g2_decap_8
XFILLER_0_194 VPWR VGND sg13g2_decap_8
XFILLER_9_217 VPWR VGND sg13g2_decap_8
XFILLER_8_294 VPWR VGND sg13g2_decap_8
XFILLER_14_70 VPWR VGND sg13g2_decap_8
XFILLER_18_349 VPWR VGND sg13g2_fill_2
XFILLER_5_242 VPWR VGND sg13g2_decap_8
XFILLER_10_28 VPWR VGND sg13g2_decap_8
Xinput7 _48_/B b[3] VPWR VGND sg13g2_buf_1
XFILLER_2_212 VPWR VGND sg13g2_decap_8
XFILLER_2_289 VPWR VGND sg13g2_decap_8
XFILLER_14_330 VPWR VGND sg13g2_decap_8
XFILLER_2_84 VPWR VGND sg13g2_decap_8
XFILLER_15_105 VPWR VGND sg13g2_decap_8
XFILLER_20_322 VPWR VGND sg13g2_decap_8
XFILLER_21_49 VPWR VGND sg13g2_decap_8
XFILLER_11_322 VPWR VGND sg13g2_decap_8
XFILLER_2_0 VPWR VGND sg13g2_decap_8
XFILLER_7_315 VPWR VGND sg13g2_decap_8
XFILLER_12_119 VPWR VGND sg13g2_decap_8
XFILLER_14_182 VPWR VGND sg13g2_decap_8
XFILLER_16_49 VPWR VGND sg13g2_decap_8
XFILLER_21_119 VPWR VGND sg13g2_decap_8
Xinput10 _34_/B b[6] VPWR VGND sg13g2_buf_1
XFILLER_11_196 VPWR VGND sg13g2_decap_8
XFILLER_20_196 VPWR VGND sg13g2_decap_8
XFILLER_7_112 VPWR VGND sg13g2_decap_8
XFILLER_19_252 VPWR VGND sg13g2_decap_8
XFILLER_7_189 VPWR VGND sg13g2_decap_8
XFILLER_4_126 VPWR VGND sg13g2_decap_8
XFILLER_0_332 VPWR VGND sg13g2_decap_8
XFILLER_17_70 VPWR VGND sg13g2_decap_8
XFILLER_3_192 VPWR VGND sg13g2_fill_1
XFILLER_13_28 VPWR VGND sg13g2_decap_8
XFILLER_0_140 VPWR VGND sg13g2_decap_8
XFILLER_13_203 VPWR VGND sg13g2_decap_8
XFILLER_12_280 VPWR VGND sg13g2_decap_8
XFILLER_8_273 VPWR VGND sg13g2_decap_8
XFILLER_5_84 VPWR VGND sg13g2_decap_8
XFILLER_10_239 VPWR VGND sg13g2_decap_8
XFILLER_18_328 VPWR VGND sg13g2_decap_8
XFILLER_6_7 VPWR VGND sg13g2_decap_8
Xinput8 _42_/B b[4] VPWR VGND sg13g2_buf_1
XFILLER_5_298 VPWR VGND sg13g2_decap_8
XFILLER_5_221 VPWR VGND sg13g2_decap_8
XFILLER_5_210 VPWR VGND sg13g2_decap_8
XFILLER_19_49 VPWR VGND sg13g2_decap_8
XFILLER_18_147 VPWR VGND sg13g2_decap_4
XFILLER_2_268 VPWR VGND sg13g2_decap_8
XFILLER_17_191 VPWR VGND sg13g2_decap_8
XFILLER_20_301 VPWR VGND sg13g2_decap_8
XFILLER_21_28 VPWR VGND sg13g2_decap_8
XFILLER_2_63 VPWR VGND sg13g2_decap_8
XFILLER_11_301 VPWR VGND sg13g2_decap_8
XFILLER_14_161 VPWR VGND sg13g2_decap_8
XFILLER_16_28 VPWR VGND sg13g2_decap_8
X_39_ _41_/A _42_/A _42_/B _52_/D VPWR VGND sg13g2_o21ai_1
Xclkbuf_1_0__f_clk _54_/CLK clkbuf_0_clk/X VPWR VGND sg13g2_buf_16
Xinput11 _28_/A rst VPWR VGND sg13g2_buf_1
XFILLER_20_175 VPWR VGND sg13g2_decap_8
XFILLER_11_175 VPWR VGND sg13g2_decap_8
XFILLER_19_231 VPWR VGND sg13g2_decap_8
XFILLER_21_7 VPWR VGND sg13g2_decap_8
XFILLER_7_168 VPWR VGND sg13g2_decap_8
XFILLER_3_330 VPWR VGND sg13g2_decap_8
XFILLER_8_84 VPWR VGND sg13g2_decap_8
XFILLER_4_105 VPWR VGND sg13g2_decap_8
XFILLER_0_311 VPWR VGND sg13g2_decap_8
XFILLER_16_223 VPWR VGND sg13g2_decap_8
XFILLER_1_119 VPWR VGND sg13g2_decap_8
XFILLER_13_259 VPWR VGND sg13g2_decap_8
XFILLER_10_0 VPWR VGND sg13g2_decap_8
XFILLER_8_252 VPWR VGND sg13g2_decap_8
XFILLER_5_63 VPWR VGND sg13g2_decap_8
XFILLER_18_307 VPWR VGND sg13g2_decap_8
Xinput9 _40_/B b[5] VPWR VGND sg13g2_buf_1
XFILLER_5_277 VPWR VGND sg13g2_decap_8
XFILLER_19_28 VPWR VGND sg13g2_decap_8
XFILLER_18_126 VPWR VGND sg13g2_decap_8
XFILLER_2_247 VPWR VGND sg13g2_decap_8
XFILLER_1_280 VPWR VGND sg13g2_decap_8
XFILLER_2_42 VPWR VGND sg13g2_decap_8
X_55_ _55_/Q _55_/CLK _55_/D _55__23/L_HI VPWR VGND sg13g2_dfrbpq_1
XFILLER_11_84 VPWR VGND sg13g2_decap_8
XFILLER_14_140 VPWR VGND sg13g2_decap_8
XFILLER_6_350 VPWR VGND sg13g2_fill_1
XFILLER_20_154 VPWR VGND sg13g2_decap_8
X_38_ _51_/D _33_/Y _37_/C _28_/A VPWR VGND sg13g2_a21oi_1
XFILLER_4_309 VPWR VGND sg13g2_decap_8
XFILLER_11_154 VPWR VGND sg13g2_decap_8
XFILLER_14_7 VPWR VGND sg13g2_decap_8
XFILLER_19_210 VPWR VGND sg13g2_decap_8
XFILLER_19_287 VPWR VGND sg13g2_decap_8
XFILLER_7_147 VPWR VGND sg13g2_decap_8
X_55__23 _55__23/L_HI VPWR VGND sg13g2_tiehi
XFILLER_8_63 VPWR VGND sg13g2_decap_8
XFILLER_16_279 VPWR VGND sg13g2_decap_8
XFILLER_3_161 VPWR VGND sg13g2_decap_8
XFILLER_13_238 VPWR VGND sg13g2_decap_8
XFILLER_21_293 VPWR VGND sg13g2_decap_8
XFILLER_8_231 VPWR VGND sg13g2_decap_8
XFILLER_5_42 VPWR VGND sg13g2_decap_8
XFILLER_14_84 VPWR VGND sg13g2_decap_8
XFILLER_5_256 VPWR VGND sg13g2_decap_8
XFILLER_14_344 VPWR VGND sg13g2_decap_8
XFILLER_18_105 VPWR VGND sg13g2_decap_8
XFILLER_2_226 VPWR VGND sg13g2_decap_8
XFILLER_20_336 VPWR VGND sg13g2_decap_8
XFILLER_2_21 VPWR VGND sg13g2_decap_8
XFILLER_2_98 VPWR VGND sg13g2_decap_8
X_54_ _54_/Q _54_/CLK _54_/D _54__22/L_HI VPWR VGND sg13g2_dfrbpq_1
XFILLER_11_336 VPWR VGND sg13g2_decap_8
XFILLER_15_119 VPWR VGND sg13g2_decap_8
XFILLER_7_329 VPWR VGND sg13g2_decap_8
XFILLER_11_63 VPWR VGND sg13g2_decap_8
XFILLER_14_196 VPWR VGND sg13g2_decap_8
XFILLER_20_133 VPWR VGND sg13g2_decap_8
X_37_ _50_/D _52_/D _37_/B _37_/C VPWR VGND sg13g2_and3_1
XFILLER_0_0 VPWR VGND sg13g2_decap_8
XFILLER_11_133 VPWR VGND sg13g2_decap_8
XFILLER_7_126 VPWR VGND sg13g2_decap_8
XFILLER_19_266 VPWR VGND sg13g2_decap_8
XFILLER_8_42 VPWR VGND sg13g2_decap_8
XFILLER_0_346 VPWR VGND sg13g2_decap_4
XFILLER_16_203 VPWR VGND sg13g2_fill_2
XFILLER_17_84 VPWR VGND sg13g2_decap_8
XFILLER_3_140 VPWR VGND sg13g2_decap_8
XFILLER_13_217 VPWR VGND sg13g2_decap_8
XFILLER_21_272 VPWR VGND sg13g2_decap_8
XFILLER_0_154 VPWR VGND sg13g2_decap_8
XFILLER_0_187 VPWR VGND sg13g2_decap_8
XFILLER_12_294 VPWR VGND sg13g2_decap_8
XFILLER_8_287 VPWR VGND sg13g2_decap_8
XFILLER_8_210 VPWR VGND sg13g2_decap_8
XFILLER_5_21 VPWR VGND sg13g2_decap_8
XFILLER_5_98 VPWR VGND sg13g2_decap_8
XFILLER_14_63 VPWR VGND sg13g2_decap_8
XFILLER_5_235 VPWR VGND sg13g2_decap_8
XFILLER_17_331 VPWR VGND sg13g2_decap_8
XFILLER_2_205 VPWR VGND sg13g2_decap_8
XFILLER_4_7 VPWR VGND sg13g2_decap_8
XFILLER_14_323 VPWR VGND sg13g2_decap_8
XFILLER_2_77 VPWR VGND sg13g2_decap_8
X_53_ _53_/Q _54_/CLK _53_/D _53__24/L_HI VPWR VGND sg13g2_dfrbpq_1
XFILLER_11_315 VPWR VGND sg13g2_decap_8
XFILLER_20_315 VPWR VGND sg13g2_decap_8
XFILLER_11_42 VPWR VGND sg13g2_decap_8
XFILLER_14_175 VPWR VGND sg13g2_decap_8
XFILLER_7_308 VPWR VGND sg13g2_decap_8
XFILLER_20_112 VPWR VGND sg13g2_decap_8
XFILLER_20_189 VPWR VGND sg13g2_decap_8
X_36_ _37_/C _36_/A _36_/B VPWR VGND sg13g2_nand2_1
XFILLER_11_112 VPWR VGND sg13g2_decap_8
XFILLER_11_189 VPWR VGND sg13g2_decap_8
XFILLER_7_105 VPWR VGND sg13g2_decap_8
XFILLER_3_344 VPWR VGND sg13g2_decap_8
XFILLER_19_245 VPWR VGND sg13g2_decap_8
XFILLER_8_98 VPWR VGND sg13g2_decap_8
XFILLER_8_21 VPWR VGND sg13g2_decap_8
XFILLER_6_182 VPWR VGND sg13g2_decap_8
XFILLER_0_325 VPWR VGND sg13g2_decap_8
XFILLER_4_119 VPWR VGND sg13g2_decap_8
XFILLER_16_215 VPWR VGND sg13g2_fill_1
XFILLER_16_237 VPWR VGND sg13g2_fill_1
XFILLER_17_63 VPWR VGND sg13g2_decap_8
XFILLER_0_133 VPWR VGND sg13g2_decap_8
XFILLER_21_251 VPWR VGND sg13g2_decap_8
XFILLER_12_273 VPWR VGND sg13g2_decap_8
XFILLER_8_266 VPWR VGND sg13g2_decap_8
XFILLER_5_77 VPWR VGND sg13g2_decap_8
XFILLER_14_42 VPWR VGND sg13g2_decap_8
XFILLER_5_203 VPWR VGND sg13g2_decap_8
XFILLER_17_310 VPWR VGND sg13g2_decap_8
XFILLER_14_302 VPWR VGND sg13g2_decap_8
XFILLER_1_294 VPWR VGND sg13g2_decap_8
XFILLER_2_56 VPWR VGND sg13g2_decap_8
X_52_ _63_/A _54_/CLK _52_/D _52__21/L_HI VPWR VGND sg13g2_dfrbpq_1
XFILLER_17_140 VPWR VGND sg13g2_decap_8
XFILLER_9_350 VPWR VGND sg13g2_fill_1
XFILLER_11_21 VPWR VGND sg13g2_decap_8
XFILLER_11_98 VPWR VGND sg13g2_decap_8
XFILLER_14_154 VPWR VGND sg13g2_decap_8
X_35_ _37_/B _36_/A _36_/B VPWR VGND sg13g2_or2_1
XFILLER_11_168 VPWR VGND sg13g2_decap_8
XFILLER_20_168 VPWR VGND sg13g2_decap_8
XFILLER_19_224 VPWR VGND sg13g2_decap_8
XFILLER_8_77 VPWR VGND sg13g2_decap_8
XFILLER_6_161 VPWR VGND sg13g2_decap_8
XFILLER_3_323 VPWR VGND sg13g2_decap_8
XFILLER_0_304 VPWR VGND sg13g2_decap_8
XFILLER_19_0 VPWR VGND sg13g2_decap_8
XFILLER_16_205 VPWR VGND sg13g2_fill_1
XFILLER_17_42 VPWR VGND sg13g2_decap_8
XFILLER_12_7 VPWR VGND sg13g2_decap_8
XFILLER_15_293 VPWR VGND sg13g2_decap_8
XFILLER_0_112 VPWR VGND sg13g2_decap_8
XFILLER_21_230 VPWR VGND sg13g2_decap_8
XFILLER_12_252 VPWR VGND sg13g2_decap_8
XFILLER_8_245 VPWR VGND sg13g2_decap_8
XFILLER_5_56 VPWR VGND sg13g2_decap_8
XFILLER_14_21 VPWR VGND sg13g2_decap_8
XFILLER_14_98 VPWR VGND sg13g2_decap_8
XFILLER_4_281 VPWR VGND sg13g2_decap_8
XFILLER_18_119 VPWR VGND sg13g2_decap_8
XFILLER_1_273 VPWR VGND sg13g2_decap_8
XFILLER_2_35 VPWR VGND sg13g2_decap_8
X_51_ _51_/Q _54_/CLK _51_/D _51__20/L_HI VPWR VGND sg13g2_dfrbpq_1
XFILLER_11_77 VPWR VGND sg13g2_decap_8
XFILLER_14_133 VPWR VGND sg13g2_decap_8
X_34_ _36_/B _34_/A _34_/B VPWR VGND sg13g2_xor2_1
XFILLER_6_343 VPWR VGND sg13g2_decap_8
XFILLER_20_147 VPWR VGND sg13g2_decap_8
XFILLER_11_147 VPWR VGND sg13g2_decap_8
XFILLER_19_203 VPWR VGND sg13g2_decap_8
XFILLER_8_56 VPWR VGND sg13g2_decap_8
XFILLER_3_302 VPWR VGND sg13g2_decap_8
XFILLER_6_140 VPWR VGND sg13g2_decap_8
XFILLER_17_21 VPWR VGND sg13g2_decap_8
XFILLER_17_98 VPWR VGND sg13g2_decap_8
XFILLER_3_154 VPWR VGND sg13g2_decap_8
XFILLER_15_272 VPWR VGND sg13g2_decap_8
XFILLER_0_168 VPWR VGND sg13g2_fill_2
XFILLER_21_286 VPWR VGND sg13g2_decap_8
XFILLER_12_231 VPWR VGND sg13g2_decap_8
XFILLER_8_224 VPWR VGND sg13g2_decap_8
XFILLER_5_35 VPWR VGND sg13g2_decap_8
XFILLER_14_77 VPWR VGND sg13g2_decap_8
XFILLER_17_345 VPWR VGND sg13g2_decap_4
XFILLER_5_249 VPWR VGND sg13g2_decap_8
XFILLER_4_260 VPWR VGND sg13g2_decap_8
XFILLER_14_337 VPWR VGND sg13g2_decap_8
XFILLER_2_219 VPWR VGND sg13g2_decap_8
XFILLER_1_252 VPWR VGND sg13g2_decap_8
XFILLER_20_329 VPWR VGND sg13g2_decap_8
XFILLER_2_14 VPWR VGND sg13g2_decap_8
X_50_ _50_/Q _55_/CLK _50_/D _50__26/L_HI VPWR VGND sg13g2_dfrbpq_1
XFILLER_9_0 VPWR VGND sg13g2_decap_8
XFILLER_11_329 VPWR VGND sg13g2_decap_8
XFILLER_11_56 VPWR VGND sg13g2_decap_8
XFILLER_2_7 VPWR VGND sg13g2_decap_8
XFILLER_14_112 VPWR VGND sg13g2_decap_8
XFILLER_14_189 VPWR VGND sg13g2_decap_8
X_33_ _33_/Y _34_/A _34_/B VPWR VGND sg13g2_nand2_1
XFILLER_6_322 VPWR VGND sg13g2_decap_8
XFILLER_20_126 VPWR VGND sg13g2_decap_8
XFILLER_9_182 VPWR VGND sg13g2_decap_8
XFILLER_11_126 VPWR VGND sg13g2_decap_8
XFILLER_19_259 VPWR VGND sg13g2_decap_8
X_49__25 _49__25/L_HI VPWR VGND sg13g2_tiehi
XFILLER_7_119 VPWR VGND sg13g2_decap_8
XFILLER_8_35 VPWR VGND sg13g2_decap_8
XFILLER_6_196 VPWR VGND sg13g2_decap_8
XFILLER_0_339 VPWR VGND sg13g2_decap_8
XFILLER_17_77 VPWR VGND sg13g2_decap_8
XFILLER_3_133 VPWR VGND sg13g2_decap_8
XFILLER_0_91 VPWR VGND sg13g2_decap_8
XFILLER_21_265 VPWR VGND sg13g2_decap_8
X_51__20 _51__20/L_HI VPWR VGND sg13g2_tiehi
XFILLER_0_147 VPWR VGND sg13g2_decap_8
XFILLER_12_210 VPWR VGND sg13g2_decap_8
XFILLER_12_287 VPWR VGND sg13g2_decap_8
Xclkbuf_1_1__f_clk _55_/CLK clkbuf_0_clk/X VPWR VGND sg13g2_buf_16
XFILLER_8_203 VPWR VGND sg13g2_decap_8
XFILLER_5_14 VPWR VGND sg13g2_decap_8
XFILLER_7_280 VPWR VGND sg13g2_decap_8
XFILLER_14_56 VPWR VGND sg13g2_decap_8
XFILLER_17_324 VPWR VGND sg13g2_decap_8
XFILLER_5_228 VPWR VGND sg13g2_decap_8
XFILLER_14_316 VPWR VGND sg13g2_decap_8
XFILLER_17_154 VPWR VGND sg13g2_fill_1
XFILLER_17_198 VPWR VGND sg13g2_decap_8
XFILLER_1_231 VPWR VGND sg13g2_decap_8
XFILLER_20_308 VPWR VGND sg13g2_decap_8
XFILLER_11_308 VPWR VGND sg13g2_decap_8
XFILLER_11_35 VPWR VGND sg13g2_decap_8
XFILLER_10_330 VPWR VGND sg13g2_decap_8
XFILLER_14_168 VPWR VGND sg13g2_decap_8
XFILLER_6_301 VPWR VGND sg13g2_decap_8
XFILLER_20_105 VPWR VGND sg13g2_decap_8
X_32_ _36_/A _40_/Y _42_/Y _29_/Y VPWR VGND sg13g2_o21ai_1
XFILLER_9_161 VPWR VGND sg13g2_decap_8
XFILLER_11_105 VPWR VGND sg13g2_decap_8
XFILLER_19_238 VPWR VGND sg13g2_decap_8
XFILLER_3_91 VPWR VGND sg13g2_decap_8
XFILLER_3_337 VPWR VGND sg13g2_decap_8
XFILLER_10_182 VPWR VGND sg13g2_decap_8
XFILLER_8_14 VPWR VGND sg13g2_decap_8
XFILLER_6_175 VPWR VGND sg13g2_decap_8
XFILLER_0_318 VPWR VGND sg13g2_decap_8
XFILLER_17_56 VPWR VGND sg13g2_decap_8
XFILLER_18_293 VPWR VGND sg13g2_decap_8
XFILLER_3_112 VPWR VGND sg13g2_decap_8
XFILLER_0_70 VPWR VGND sg13g2_decap_8
XFILLER_17_0 VPWR VGND sg13g2_decap_8
XFILLER_21_244 VPWR VGND sg13g2_decap_8
XFILLER_0_126 VPWR VGND sg13g2_decap_8
XFILLER_12_266 VPWR VGND sg13g2_decap_8
XFILLER_8_259 VPWR VGND sg13g2_decap_8
XFILLER_10_7 VPWR VGND sg13g2_decap_8
XFILLER_14_35 VPWR VGND sg13g2_decap_8
XFILLER_17_303 VPWR VGND sg13g2_decap_8
XFILLER_4_295 VPWR VGND sg13g2_decap_8
XFILLER_6_91 VPWR VGND sg13g2_decap_8
XFILLER_17_133 VPWR VGND sg13g2_decap_8
XFILLER_1_210 VPWR VGND sg13g2_decap_8
XFILLER_1_287 VPWR VGND sg13g2_decap_8
XFILLER_2_49 VPWR VGND sg13g2_decap_8
XFILLER_13_350 VPWR VGND sg13g2_fill_1
XFILLER_9_343 VPWR VGND sg13g2_decap_8
XFILLER_11_14 VPWR VGND sg13g2_decap_8
XFILLER_14_147 VPWR VGND sg13g2_decap_8
X_31_ _54_/D _45_/Y _48_/Y _30_/Y VPWR VGND sg13g2_a21oi_1
XFILLER_9_140 VPWR VGND sg13g2_decap_8
XFILLER_3_70 VPWR VGND sg13g2_decap_8
XFILLER_3_316 VPWR VGND sg13g2_decap_8
XFILLER_10_161 VPWR VGND sg13g2_decap_8
XFILLER_19_217 VPWR VGND sg13g2_decap_8
XFILLER_6_154 VPWR VGND sg13g2_decap_8
XFILLER_18_272 VPWR VGND sg13g2_decap_8
XFILLER_17_35 VPWR VGND sg13g2_decap_8
XFILLER_3_168 VPWR VGND sg13g2_decap_4
XFILLER_15_286 VPWR VGND sg13g2_decap_8
XFILLER_0_105 VPWR VGND sg13g2_decap_8
XFILLER_12_245 VPWR VGND sg13g2_decap_8
XFILLER_21_223 VPWR VGND sg13g2_decap_8
XFILLER_9_91 VPWR VGND sg13g2_decap_8
XFILLER_8_238 VPWR VGND sg13g2_decap_8
XFILLER_5_49 VPWR VGND sg13g2_decap_8
XFILLER_14_14 VPWR VGND sg13g2_decap_8
XFILLER_4_274 VPWR VGND sg13g2_decap_8
XFILLER_6_70 VPWR VGND sg13g2_decap_8
XFILLER_17_112 VPWR VGND sg13g2_decap_8
XFILLER_1_266 VPWR VGND sg13g2_decap_8
XFILLER_2_28 VPWR VGND sg13g2_decap_8
XFILLER_9_322 VPWR VGND sg13g2_decap_8
XFILLER_14_126 VPWR VGND sg13g2_decap_8
X_30_ _30_/Y _45_/Y _48_/Y _52_/D VPWR VGND sg13g2_o21ai_1
XFILLER_7_0 VPWR VGND sg13g2_decap_8
XFILLER_6_336 VPWR VGND sg13g2_decap_8
XFILLER_9_196 VPWR VGND sg13g2_decap_8
XFILLER_0_7 VPWR VGND sg13g2_decap_8
XFILLER_10_140 VPWR VGND sg13g2_decap_8
XFILLER_12_91 VPWR VGND sg13g2_decap_8
XFILLER_8_49 VPWR VGND sg13g2_decap_8
XFILLER_6_133 VPWR VGND sg13g2_decap_8
XFILLER_18_251 VPWR VGND sg13g2_decap_8
XFILLER_17_14 VPWR VGND sg13g2_decap_8
XFILLER_3_147 VPWR VGND sg13g2_decap_8
XFILLER_15_221 VPWR VGND sg13g2_decap_8
XFILLER_15_265 VPWR VGND sg13g2_decap_8
XFILLER_21_279 VPWR VGND sg13g2_decap_8
XFILLER_9_70 VPWR VGND sg13g2_decap_8
XFILLER_12_224 VPWR VGND sg13g2_decap_8
XFILLER_8_217 VPWR VGND sg13g2_decap_8
XFILLER_5_28 VPWR VGND sg13g2_decap_8
XFILLER_7_294 VPWR VGND sg13g2_decap_8
XFILLER_17_338 VPWR VGND sg13g2_decap_8
XFILLER_17_349 VPWR VGND sg13g2_fill_2
XFILLER_20_91 VPWR VGND sg13g2_decap_8
XFILLER_4_253 VPWR VGND sg13g2_decap_8
XFILLER_1_245 VPWR VGND sg13g2_decap_8
XFILLER_15_91 VPWR VGND sg13g2_decap_8
XFILLER_9_301 VPWR VGND sg13g2_decap_8
XFILLER_11_49 VPWR VGND sg13g2_decap_8
XFILLER_10_344 VPWR VGND sg13g2_decap_8
XFILLER_14_105 VPWR VGND sg13g2_decap_8
XFILLER_6_315 VPWR VGND sg13g2_decap_8
XFILLER_11_119 VPWR VGND sg13g2_decap_8
XFILLER_13_182 VPWR VGND sg13g2_decap_8
XFILLER_20_119 VPWR VGND sg13g2_decap_8
XFILLER_9_175 VPWR VGND sg13g2_decap_8
XFILLER_8_28 VPWR VGND sg13g2_decap_8
XFILLER_10_196 VPWR VGND sg13g2_decap_8
XFILLER_12_70 VPWR VGND sg13g2_decap_8
XFILLER_18_230 VPWR VGND sg13g2_decap_8
XFILLER_6_189 VPWR VGND sg13g2_decap_8
XFILLER_6_112 VPWR VGND sg13g2_decap_8
XFILLER_3_126 VPWR VGND sg13g2_decap_8
XFILLER_15_200 VPWR VGND sg13g2_decap_8
XFILLER_0_84 VPWR VGND sg13g2_decap_8
XFILLER_21_258 VPWR VGND sg13g2_decap_8
XFILLER_12_203 VPWR VGND sg13g2_decap_8
XFILLER_20_280 VPWR VGND sg13g2_decap_8
XFILLER_11_280 VPWR VGND sg13g2_decap_8
XFILLER_15_0 VPWR VGND sg13g2_decap_8
XFILLER_18_91 VPWR VGND sg13g2_decap_8
XFILLER_7_273 VPWR VGND sg13g2_decap_8
XFILLER_14_49 VPWR VGND sg13g2_decap_8
XFILLER_17_317 VPWR VGND sg13g2_decap_8
XFILLER_20_70 VPWR VGND sg13g2_decap_8
XFILLER_14_309 VPWR VGND sg13g2_decap_8
XFILLER_15_70 VPWR VGND sg13g2_decap_8
XFILLER_17_147 VPWR VGND sg13g2_decap_8
XFILLER_1_224 VPWR VGND sg13g2_decap_8
XFILLER_0_290 VPWR VGND sg13g2_decap_8
XFILLER_11_28 VPWR VGND sg13g2_decap_8
XFILLER_10_323 VPWR VGND sg13g2_decap_8
XFILLER_13_161 VPWR VGND sg13g2_decap_8
XFILLER_9_154 VPWR VGND sg13g2_decap_8
XFILLER_3_84 VPWR VGND sg13g2_decap_8
XFILLER_10_175 VPWR VGND sg13g2_decap_8
XFILLER_18_286 VPWR VGND sg13g2_decap_8
XFILLER_19_7 VPWR VGND sg13g2_decap_8
XFILLER_6_168 VPWR VGND sg13g2_decap_8
XFILLER_17_49 VPWR VGND sg13g2_decap_8
X_54__22 _54__22/L_HI VPWR VGND sg13g2_tiehi
XFILLER_3_105 VPWR VGND sg13g2_decap_8
XFILLER_0_63 VPWR VGND sg13g2_decap_8
XFILLER_21_237 VPWR VGND sg13g2_decap_8
XFILLER_0_119 VPWR VGND sg13g2_decap_8
XFILLER_12_259 VPWR VGND sg13g2_decap_8
XFILLER_18_70 VPWR VGND sg13g2_decap_8
XFILLER_7_252 VPWR VGND sg13g2_decap_8
XFILLER_14_28 VPWR VGND sg13g2_decap_8
XFILLER_4_288 VPWR VGND sg13g2_decap_8
XFILLER_4_211 VPWR VGND sg13g2_fill_1
XFILLER_6_84 VPWR VGND sg13g2_decap_8
XFILLER_13_343 VPWR VGND sg13g2_decap_8
XFILLER_17_126 VPWR VGND sg13g2_decap_8
XFILLER_1_203 VPWR VGND sg13g2_decap_8
XFILLER_9_336 VPWR VGND sg13g2_decap_8
XFILLER_10_302 VPWR VGND sg13g2_decap_8
XFILLER_13_140 VPWR VGND sg13g2_decap_8
XFILLER_9_133 VPWR VGND sg13g2_decap_8
XFILLER_3_63 VPWR VGND sg13g2_decap_8
XFILLER_3_309 VPWR VGND sg13g2_decap_8
XFILLER_10_154 VPWR VGND sg13g2_decap_8
XFILLER_18_265 VPWR VGND sg13g2_decap_8
XFILLER_2_331 VPWR VGND sg13g2_decap_8
XFILLER_6_147 VPWR VGND sg13g2_decap_8
XFILLER_5_0 VPWR VGND sg13g2_decap_8
XFILLER_17_28 VPWR VGND sg13g2_decap_8
XFILLER_15_235 VPWR VGND sg13g2_fill_2
XFILLER_15_279 VPWR VGND sg13g2_decap_8
XFILLER_0_42 VPWR VGND sg13g2_decap_8
XFILLER_21_205 VPWR VGND sg13g2_decap_4
XFILLER_2_161 VPWR VGND sg13g2_decap_8
XFILLER_9_84 VPWR VGND sg13g2_decap_8
XFILLER_12_238 VPWR VGND sg13g2_decap_8
XFILLER_7_231 VPWR VGND sg13g2_decap_8
XFILLER_4_267 VPWR VGND sg13g2_decap_8
XFILLER_20_0 VPWR VGND sg13g2_decap_8
XFILLER_6_63 VPWR VGND sg13g2_decap_8
XFILLER_13_322 VPWR VGND sg13g2_decap_8
XFILLER_17_105 VPWR VGND sg13g2_decap_8
XFILLER_1_259 VPWR VGND sg13g2_decap_8
XFILLER_9_7 VPWR VGND sg13g2_decap_8
XFILLER_9_315 VPWR VGND sg13g2_decap_8
XFILLER_14_119 VPWR VGND sg13g2_decap_8
XFILLER_6_329 VPWR VGND sg13g2_decap_8
XFILLER_13_196 VPWR VGND sg13g2_decap_8
XFILLER_9_189 VPWR VGND sg13g2_decap_8
XFILLER_9_112 VPWR VGND sg13g2_decap_8
XFILLER_5_340 VPWR VGND sg13g2_decap_8
XFILLER_3_42 VPWR VGND sg13g2_decap_8
XFILLER_10_133 VPWR VGND sg13g2_decap_8
XFILLER_12_84 VPWR VGND sg13g2_decap_8
XFILLER_2_310 VPWR VGND sg13g2_decap_8
XFILLER_6_126 VPWR VGND sg13g2_decap_8
XFILLER_18_244 VPWR VGND sg13g2_decap_8
XFILLER_15_214 VPWR VGND sg13g2_decap_8
XFILLER_0_21 VPWR VGND sg13g2_decap_8
XFILLER_0_98 VPWR VGND sg13g2_decap_8
XFILLER_2_140 VPWR VGND sg13g2_decap_8
XFILLER_12_217 VPWR VGND sg13g2_decap_8
XFILLER_9_63 VPWR VGND sg13g2_decap_8
XFILLER_11_294 VPWR VGND sg13g2_decap_8
XFILLER_20_294 VPWR VGND sg13g2_decap_8
XFILLER_7_210 VPWR VGND sg13g2_decap_8
XFILLER_19_350 VPWR VGND sg13g2_fill_1
XFILLER_7_287 VPWR VGND sg13g2_decap_8
XFILLER_20_84 VPWR VGND sg13g2_decap_8
XFILLER_4_246 VPWR VGND sg13g2_decap_8
XFILLER_4_202 VPWR VGND sg13g2_decap_8
XFILLER_16_342 VPWR VGND sg13g2_fill_1
XFILLER_6_42 VPWR VGND sg13g2_decap_8
XFILLER_13_0 VPWR VGND sg13g2_decap_8
XFILLER_1_238 VPWR VGND sg13g2_decap_8
XFILLER_13_301 VPWR VGND sg13g2_decap_8
XFILLER_15_84 VPWR VGND sg13g2_decap_8
XFILLER_10_337 VPWR VGND sg13g2_decap_8
XFILLER_13_175 VPWR VGND sg13g2_decap_8
XFILLER_6_308 VPWR VGND sg13g2_decap_8
XFILLER_3_21 VPWR VGND sg13g2_decap_8
XFILLER_9_168 VPWR VGND sg13g2_decap_8
XFILLER_3_98 VPWR VGND sg13g2_decap_8
XFILLER_10_112 VPWR VGND sg13g2_decap_8
XFILLER_10_189 VPWR VGND sg13g2_decap_8
XFILLER_12_63 VPWR VGND sg13g2_decap_8
XFILLER_6_105 VPWR VGND sg13g2_decap_8
XFILLER_18_223 VPWR VGND sg13g2_decap_8
XFILLER_5_182 VPWR VGND sg13g2_decap_8
XFILLER_3_119 VPWR VGND sg13g2_decap_8
XFILLER_15_237 VPWR VGND sg13g2_fill_1
XFILLER_17_7 VPWR VGND sg13g2_decap_8
XFILLER_0_77 VPWR VGND sg13g2_decap_8
XFILLER_14_281 VPWR VGND sg13g2_decap_8
XFILLER_9_42 VPWR VGND sg13g2_decap_8
XFILLER_18_84 VPWR VGND sg13g2_decap_8
XFILLER_20_273 VPWR VGND sg13g2_decap_8
XFILLER_11_273 VPWR VGND sg13g2_decap_8
XFILLER_7_266 VPWR VGND sg13g2_decap_8
XFILLER_16_321 VPWR VGND sg13g2_decap_8
XFILLER_20_63 VPWR VGND sg13g2_decap_8
XFILLER_6_98 VPWR VGND sg13g2_decap_8
XFILLER_6_21 VPWR VGND sg13g2_decap_8
XFILLER_1_217 VPWR VGND sg13g2_decap_8
XFILLER_0_283 VPWR VGND sg13g2_decap_8
XFILLER_15_63 VPWR VGND sg13g2_decap_8
XFILLER_16_140 VPWR VGND sg13g2_decap_8
XFILLER_8_350 VPWR VGND sg13g2_fill_1
XFILLER_10_316 VPWR VGND sg13g2_decap_8
XFILLER_13_154 VPWR VGND sg13g2_decap_8
XFILLER_9_147 VPWR VGND sg13g2_decap_8
XFILLER_3_77 VPWR VGND sg13g2_decap_8
XFILLER_10_168 VPWR VGND sg13g2_decap_8
XFILLER_12_42 VPWR VGND sg13g2_decap_8
XFILLER_18_202 VPWR VGND sg13g2_decap_8
XFILLER_18_279 VPWR VGND sg13g2_decap_8
XFILLER_2_345 VPWR VGND sg13g2_decap_4
XFILLER_5_161 VPWR VGND sg13g2_decap_8
XFILLER_2_175 VPWR VGND sg13g2_fill_2
XFILLER_3_0 VPWR VGND sg13g2_decap_8
XFILLER_0_56 VPWR VGND sg13g2_decap_8
XFILLER_14_260 VPWR VGND sg13g2_decap_8
XFILLER_9_21 VPWR VGND sg13g2_decap_8
XFILLER_9_98 VPWR VGND sg13g2_decap_8
XFILLER_18_63 VPWR VGND sg13g2_decap_8
XFILLER_20_252 VPWR VGND sg13g2_decap_8
XFILLER_11_252 VPWR VGND sg13g2_decap_8
XFILLER_7_245 VPWR VGND sg13g2_decap_8
XFILLER_16_300 VPWR VGND sg13g2_decap_8
XFILLER_20_42 VPWR VGND sg13g2_decap_8
XFILLER_19_182 VPWR VGND sg13g2_decap_8
XFILLER_6_77 VPWR VGND sg13g2_decap_8
XFILLER_3_281 VPWR VGND sg13g2_decap_8
XFILLER_13_336 VPWR VGND sg13g2_decap_8
XFILLER_15_42 VPWR VGND sg13g2_decap_8
XFILLER_17_119 VPWR VGND sg13g2_decap_8
XFILLER_9_329 VPWR VGND sg13g2_decap_8
XFILLER_0_262 VPWR VGND sg13g2_decap_8
XFILLER_16_196 VPWR VGND sg13g2_decap_8
.ends
